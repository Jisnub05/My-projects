# Ansys Electronics Desktop project, version 2024.2
materials:
  vacuum: permittivity=1
  Rogers RT/duroid 5880 (tm): permittivity=2.2 dielectric_loss_tangent=0.0009
  pec: conductivity=1e+30
  air: permittivity=1.0006 permeability=1.0000004
  Arlon AD270 (tm): permittivity=2.7 dielectric_loss_tangent=0.0023
  Teflon (tm): permittivity=2.1 dielectric_loss_tangent=0.001
  copper: permeability=0.999991 conductivity=58000000

design HFSSDesign1 (HFSS, HFSS Terminal Network, model units mm)
variables:
  wend = 1.959mm
  lsubs = 21.963mm
  hs = 0.635mm
  l2 = 10.576mm
  lshift = 10mm
  lhori = 4.807mm
  lside = 8.621mm
  w2 = 2.644mm
  w1 = 1.602mm
  l1 = 7.4mm
  hsubst = 0.635mm
  h = 2.5mm
  Cuthick = 0.05mm
geometry:
  Rectangle8 = rectangle(corner=(-l2/2, -(l1+2*w2)/2, hs), x_size=l2, y_size=(l1+2*w2))
  Rectangle14 = rectangle(corner=(-(l2-2*w1)/2, -l1/2, hs), x_size=l2-2*w1, y_size=l1)
  Rectangle8.subtract(Rectangle14)
  Rectangle15 = rectangle(corner=(-l2/2, l1/2, hs), x_size=-lside, y_size=w1)
  Rectangle16 = rectangle(corner=(-l2/2, -l1/2, hs), x_size=-lside, y_size=-w1)
  Rectangle17 = rectangle(corner=(l2/2, -l1/2, hs), x_size=lside, y_size=-w1)
  Rectangle18 = rectangle(corner=(l2/2, l1/2, hs), x_size=lside, y_size=w1)
  Rectangle8.unite(Rectangle15..Rectangle18)
  Rectangle19 = rectangle(corner=(-l2/2, -(l1+2*w2)/2, hs), x_size=l2, y_size=(l1+2*w2))
  Rectangle9 = rectangle(corner=(-(l2-2*w1)/2, -l1/2, hs), x_size=l2-2*w1, y_size=l1)
  Rectangle19.subtract(Rectangle9)
  Rectangle10 = rectangle(corner=(-l2/2, l1/2, hs), x_size=-lside, y_size=w1)
  Rectangle11 = rectangle(corner=(-l2/2, -l1/2, hs), x_size=-lside, y_size=-w1)
  Rectangle12 = rectangle(corner=(l2/2, -l1/2, hs), x_size=lside, y_size=-w1)
  Rectangle13 = rectangle(corner=(l2/2, l1/2, hs), x_size=lside, y_size=w1)
  Rectangle19.unite(Rectangle10..Rectangle13)
  Rectangle19.move(19.136mm, 0mm, 0mm)
  Rectangle8.unite(Rectangle19)
  Rectangle8.move(19.136mm, -6.197mm, 0mm)
  Rectangle20 = rectangle(corner=(-l2/2, -(l1+2*w2)/2, hs), x_size=l2, y_size=(l1+2*w2))
  Rectangle21 = rectangle(corner=(-(l2-2*w1)/2, -l1/2, hs), x_size=l2-2*w1, y_size=l1)
  Rectangle20.subtract(Rectangle21)
  Rectangle22 = rectangle(corner=(-l2/2, l1/2, hs), x_size=-lside, y_size=w1)
  Rectangle23 = rectangle(corner=(-l2/2, -l1/2, hs), x_size=-lside, y_size=-w1)
  Rectangle24 = rectangle(corner=(l2/2, -l1/2, hs), x_size=lside, y_size=-w1)
  Rectangle25 = rectangle(corner=(l2/2, l1/2, hs), x_size=lside, y_size=w1)
  Rectangle20.unite(Rectangle22..Rectangle25)
  Rectangle20.move(-8.682mm, 2.805mm, 0mm)
  Rectangle20.move(0mm, -18.004mm, 0mm)
  Rectangle26 = rectangle(corner=(-l2/2, -(l1+2*w2)/2, hs), x_size=l2, y_size=(l1+2*w2))
  Rectangle27 = rectangle(corner=(-(l2-2*w1)/2, -l1/2, hs), x_size=l2-2*w1, y_size=l1)
  Rectangle26.subtract(Rectangle27)
  Rectangle28 = rectangle(corner=(-l2/2, l1/2, hs), x_size=-lside, y_size=w1)
  Rectangle29 = rectangle(corner=(-l2/2, -l1/2, hs), x_size=-lside, y_size=-w1)
  Rectangle30 = rectangle(corner=(l2/2, -l1/2, hs), x_size=lside, y_size=-w1)
  Rectangle31 = rectangle(corner=(l2/2, l1/2, hs), x_size=lside, y_size=w1)
  Rectangle26.unite(Rectangle28..Rectangle31)
  Rectangle26.move(-8.682mm, 2.805mm, 0mm)
  Rectangle26.move(74.772mm, -4.4408921e-16mm, 0mm)
  Rectangle32 = rectangle(corner=(l2/2, l1/2, hs), x_size=lside, y_size=w1)
  Rectangle33 = rectangle(corner=(-l2/2, -(l1+2*w2)/2, hs), x_size=l2, y_size=(l1+2*w2))
  Rectangle34 = rectangle(corner=(-(l2-2*w1)/2, -l1/2, hs), x_size=l2-2*w1, y_size=l1)
  Rectangle33.subtract(Rectangle34)
  Rectangle35 = rectangle(corner=(-l2/2, -l1/2, hs), x_size=-lside, y_size=-w1)
  Rectangle32.unite(Rectangle33, Rectangle35)
  Rectangle36 = rectangle(corner=(l2/2, -l1/2, hs), x_size=lside, y_size=-w1)
  Rectangle38 = rectangle(corner=(l2/2, l1/2, hs), x_size=lside, y_size=w1)
  Rectangle39 = rectangle(corner=(-l2/2, -(l1+2*w2)/2, hs), x_size=l2, y_size=(l1+2*w2))
  Rectangle40 = rectangle(corner=(-(l2-2*w1)/2, -l1/2, hs), x_size=l2-2*w1, y_size=l1)
  Rectangle39.subtract(Rectangle40)
  Rectangle41 = rectangle(corner=(-l2/2, -l1/2, hs), x_size=-lside, y_size=-w1)
  Rectangle38.unite(Rectangle39, Rectangle41)
  Rectangle38.move(19.136mm, 0mm, 0mm)
  Rectangle37 = rectangle(corner=(l2/2, l1/2, hs), x_size=lside, y_size=w1)
  Rectangle37.move(5.93mm, 0mm, 0mm)
  Rectangle32.unite(Rectangle36, Rectangle38, Rectangle37)
  Rectangle32.move(19.136mm, 11.807mm, 0mm)
  Rectangle42 = rectangle(corner=(52.181mm, 6.505mm, hs), x_size=-w1, y_size=9.002mm)
  Rectangle43 = rectangle(corner=(-l2/2, -(l1+2*w2)/2, hs), x_size=l2, y_size=(l1+2*w2))
  Rectangle44 = rectangle(corner=(-(l2-2*w1)/2, -l1/2, hs), x_size=l2-2*w1, y_size=l1)
  Rectangle43.subtract(Rectangle44)
  Rectangle45 = rectangle(corner=(-l2/2, l1/2, hs), x_size=-lside, y_size=w1)
  Rectangle46 = rectangle(corner=(-l2/2, -l1/2, hs), x_size=-lside, y_size=-w1)
  Rectangle47 = rectangle(corner=(l2/2, -l1/2, hs), x_size=lside, y_size=-w1)
  Rectangle48 = rectangle(corner=(l2/2, l1/2, hs), x_size=lside, y_size=w1)
  Rectangle43.unite(Rectangle45..Rectangle48)
  Rectangle43.move(-8.682mm, 2.805mm, 0mm)
  Rectangle43.move(74.772mm, -4.4408921e-16mm, 0mm)
  Rectangle43.move(1.4210855e-14mm, -18.004mm, 0mm)
  Rectangle59 = rectangle(corner=(52.181mm, 6.505mm, hs), x_size=-w1, y_size=9.002mm)
  Rectangle59.move(-46.954mm, -36.008mm, 0mm)
  Rectangle59.move(48.556mm, 0mm, 0mm)
  Rectangle60 = rectangle(corner=(-l2/2, -(l1+2*w2)/2, hs), x_size=l2, y_size=(l1+2*w2))
  Rectangle61 = rectangle(corner=(-(l2-2*w1)/2, -l1/2, hs), x_size=l2-2*w1, y_size=l1)
  Rectangle60.subtract(Rectangle61)
  Rectangle62 = rectangle(corner=(-l2/2, l1/2, hs), x_size=-lside, y_size=w1)
  Rectangle63 = rectangle(corner=(-l2/2, -l1/2, hs), x_size=-lside, y_size=-w1)
  Rectangle64 = rectangle(corner=(l2/2, -l1/2, hs), x_size=lside, y_size=-w1)
  Rectangle65 = rectangle(corner=(l2/2, l1/2, hs), x_size=lside, y_size=w1)
  Rectangle60.unite(Rectangle62..Rectangle65)
  Rectangle66 = rectangle(corner=(-l2/2, -(l1+2*w2)/2, hs), x_size=l2, y_size=(l1+2*w2))
  Rectangle67 = rectangle(corner=(-(l2-2*w1)/2, -l1/2, hs), x_size=l2-2*w1, y_size=l1)
  Rectangle66.subtract(Rectangle67)
  Rectangle68 = rectangle(corner=(-l2/2, l1/2, hs), x_size=-lside, y_size=w1)
  Rectangle69 = rectangle(corner=(-l2/2, -l1/2, hs), x_size=-lside, y_size=-w1)
  Rectangle70 = rectangle(corner=(l2/2, -l1/2, hs), x_size=lside, y_size=-w1)
  Rectangle71 = rectangle(corner=(l2/2, l1/2, hs), x_size=lside, y_size=w1)
  Rectangle66.unite(Rectangle68..Rectangle71)
  Rectangle66.move(19.136mm, 0mm, 0mm)
  Rectangle60.unite(Rectangle66)
  Rectangle60.move(19.136mm, -6.197mm, 0mm)
  Rectangle60.move(74.772mm, -8.8817842e-16mm, 0mm)
  Rectangle72 = rectangle(corner=(l2/2, l1/2, hs), x_size=lside, y_size=w1)
  Rectangle73 = rectangle(corner=(-l2/2, -(l1+2*w2)/2, hs), x_size=l2, y_size=(l1+2*w2))
  Rectangle74 = rectangle(corner=(-(l2-2*w1)/2, -l1/2, hs), x_size=l2-2*w1, y_size=l1)
  Rectangle73.subtract(Rectangle74)
  Rectangle75 = rectangle(corner=(-l2/2, -l1/2, hs), x_size=-lside, y_size=-w1)
  Rectangle72.unite(Rectangle73, Rectangle75)
  Rectangle76 = rectangle(corner=(l2/2, -l1/2, hs), x_size=lside, y_size=-w1)
  Rectangle78 = rectangle(corner=(l2/2, l1/2, hs), x_size=lside, y_size=w1)
  Rectangle79 = rectangle(corner=(-l2/2, -(l1+2*w2)/2, hs), x_size=l2, y_size=(l1+2*w2))
  Rectangle80 = rectangle(corner=(-(l2-2*w1)/2, -l1/2, hs), x_size=l2-2*w1, y_size=l1)
  Rectangle79.subtract(Rectangle80)
  Rectangle81 = rectangle(corner=(-l2/2, -l1/2, hs), x_size=-lside, y_size=-w1)
  Rectangle78.unite(Rectangle79, Rectangle81)
  Rectangle78.move(19.136mm, 0mm, 0mm)
  Rectangle77 = rectangle(corner=(l2/2, l1/2, hs), x_size=lside, y_size=w1)
  Rectangle77.move(5.93mm, 0mm, 0mm)
  Rectangle72.unite(Rectangle76, Rectangle78, Rectangle77)
  Rectangle72.move(19.136mm, 11.807mm, 0mm)
  Rectangle72.move(74.772mm, 8.8817842e-16mm, 0mm)
  Rectangle107 = rectangle(corner=(186.434mm, 8.107mm, hs), x_size=-w1, y_size=9.002mm)
  Rectangle107.move(20.168mm, -27.109mm, -0.635mm)
  Rectangle107.move(-79.649mm, 36.111mm, 0.635mm)
  Rectangle122 = rectangle(corner=(-l2/2, -(l1+2*w2)/2, hs), x_size=l2, y_size=(l1+2*w2))
  Rectangle123 = rectangle(corner=(-(l2-2*w1)/2, -l1/2, hs), x_size=l2-2*w1, y_size=l1)
  Rectangle122.subtract(Rectangle123)
  Rectangle124 = rectangle(corner=(-l2/2, l1/2, hs), x_size=-lside, y_size=w1)
  Rectangle125 = rectangle(corner=(-l2/2, -l1/2, hs), x_size=-lside, y_size=-w1)
  Rectangle126 = rectangle(corner=(l2/2, -l1/2, hs), x_size=lside, y_size=-w1)
  Rectangle127 = rectangle(corner=(l2/2, l1/2, hs), x_size=lside, y_size=w1)
  Rectangle122.unite(Rectangle124..Rectangle127)
  Rectangle128 = rectangle(corner=(-l2/2, -(l1+2*w2)/2, hs), x_size=l2, y_size=(l1+2*w2))
  Rectangle129 = rectangle(corner=(-(l2-2*w1)/2, -l1/2, hs), x_size=l2-2*w1, y_size=l1)
  Rectangle128.subtract(Rectangle129)
  Rectangle130 = rectangle(corner=(-l2/2, l1/2, hs), x_size=-lside, y_size=w1)
  Rectangle131 = rectangle(corner=(-l2/2, -l1/2, hs), x_size=-lside, y_size=-w1)
  Rectangle132 = rectangle(corner=(l2/2, -l1/2, hs), x_size=lside, y_size=-w1)
  Rectangle133 = rectangle(corner=(l2/2, l1/2, hs), x_size=lside, y_size=w1)
  Rectangle128.unite(Rectangle130..Rectangle133)
  Rectangle128.move(19.136mm, 0mm, 0mm)
  Rectangle122.unite(Rectangle128)
  Rectangle122.move(19.136mm, -6.197mm, 0mm)
  Rectangle122.move(74.772mm, -8.8817842e-16mm, 0mm)
  Rectangle122.move(46.954mm, -9.002mm, 0mm)
  Rectangle134 = rectangle(corner=(-l2/2, -(l1+2*w2)/2, hs), x_size=l2, y_size=(l1+2*w2))
  Rectangle135 = rectangle(corner=(-(l2-2*w1)/2, -l1/2, hs), x_size=l2-2*w1, y_size=l1)
  Rectangle134.subtract(Rectangle135)
  Rectangle136 = rectangle(corner=(-l2/2, l1/2, hs), x_size=-lside, y_size=w1)
  Rectangle137 = rectangle(corner=(-l2/2, -l1/2, hs), x_size=-lside, y_size=-w1)
  Rectangle138 = rectangle(corner=(l2/2, -l1/2, hs), x_size=lside, y_size=-w1)
  Rectangle139 = rectangle(corner=(l2/2, l1/2, hs), x_size=lside, y_size=w1)
  Rectangle134.unite(Rectangle136..Rectangle139)
  Rectangle140 = rectangle(corner=(-l2/2, -(l1+2*w2)/2, hs), x_size=l2, y_size=(l1+2*w2))
  Rectangle141 = rectangle(corner=(-(l2-2*w1)/2, -l1/2, hs), x_size=l2-2*w1, y_size=l1)
  Rectangle140.subtract(Rectangle141)
  Rectangle142 = rectangle(corner=(-l2/2, l1/2, hs), x_size=-lside, y_size=w1)
  Rectangle143 = rectangle(corner=(-l2/2, -l1/2, hs), x_size=-lside, y_size=-w1)
  Rectangle144 = rectangle(corner=(l2/2, -l1/2, hs), x_size=lside, y_size=-w1)
  Rectangle145 = rectangle(corner=(l2/2, l1/2, hs), x_size=lside, y_size=w1)
  Rectangle140.unite(Rectangle142..Rectangle145)
  Rectangle140.move(19.136mm, 0mm, 0mm)
  Rectangle134.unite(Rectangle140)
  Rectangle134.move(19.136mm, -6.197mm, 0mm)
  Rectangle134.move(74.772mm, -8.8817842e-16mm, 0mm)
  Rectangle134.move(46.954mm, -9.002mm, 0mm)
  Rectangle134.move(-46.954mm, -9.002mm, 0mm)
  Rectangle147 = rectangle(corner=(l2/2, l1/2, hs), x_size=lside, y_size=w1)
  Rectangle148 = rectangle(corner=(-l2/2, -(l1+2*w2)/2, hs), x_size=l2, y_size=(l1+2*w2))
  Rectangle149 = rectangle(corner=(-(l2-2*w1)/2, -l1/2, hs), x_size=l2-2*w1, y_size=l1)
  Rectangle148.subtract(Rectangle149)
  Rectangle150 = rectangle(corner=(-l2/2, -l1/2, hs), x_size=-lside, y_size=-w1)
  Rectangle147.unite(Rectangle148, Rectangle150)
  Rectangle151 = rectangle(corner=(l2/2, -l1/2, hs), x_size=lside, y_size=-w1)
  Rectangle153 = rectangle(corner=(l2/2, l1/2, hs), x_size=lside, y_size=w1)
  Rectangle154 = rectangle(corner=(-l2/2, -(l1+2*w2)/2, hs), x_size=l2, y_size=(l1+2*w2))
  Rectangle155 = rectangle(corner=(-(l2-2*w1)/2, -l1/2, hs), x_size=l2-2*w1, y_size=l1)
  Rectangle154.subtract(Rectangle155)
  Rectangle156 = rectangle(corner=(-l2/2, -l1/2, hs), x_size=-lside, y_size=-w1)
  Rectangle153.unite(Rectangle154, Rectangle156)
  Rectangle153.move(19.136mm, 0mm, 0mm)
  Rectangle152 = rectangle(corner=(l2/2, l1/2, hs), x_size=lside, y_size=w1)
  Rectangle152.move(5.93mm, 0mm, 0mm)
  Rectangle147.unite(Rectangle151, Rectangle153, Rectangle152)
  Rectangle147.move(19.136mm, 11.807mm, 0mm)
  Rectangle147.move(74.772mm, 8.8817842e-16mm, 0mm)
  Rectangle147.move(46.954mm, -9.002mm, 0mm)
  Rectangle157 = rectangle(corner=(-l2/2, -(l1+2*w2)/2, hs), x_size=l2, y_size=(l1+2*w2))
  Rectangle158 = rectangle(corner=(-(l2-2*w1)/2, -l1/2, hs), x_size=l2-2*w1, y_size=l1)
  Rectangle157.subtract(Rectangle158)
  Rectangle159 = rectangle(corner=(-l2/2, l1/2, hs), x_size=-lside, y_size=w1)
  Rectangle160 = rectangle(corner=(-l2/2, -l1/2, hs), x_size=-lside, y_size=-w1)
  Rectangle161 = rectangle(corner=(l2/2, -l1/2, hs), x_size=lside, y_size=-w1)
  Rectangle162 = rectangle(corner=(l2/2, l1/2, hs), x_size=lside, y_size=w1)
  Rectangle157.unite(Rectangle159..Rectangle162)
  Rectangle163 = rectangle(corner=(-l2/2, -(l1+2*w2)/2, hs), x_size=l2, y_size=(l1+2*w2))
  Rectangle164 = rectangle(corner=(-(l2-2*w1)/2, -l1/2, hs), x_size=l2-2*w1, y_size=l1)
  Rectangle163.subtract(Rectangle164)
  Rectangle165 = rectangle(corner=(-l2/2, l1/2, hs), x_size=-lside, y_size=w1)
  Rectangle166 = rectangle(corner=(-l2/2, -l1/2, hs), x_size=-lside, y_size=-w1)
  Rectangle167 = rectangle(corner=(l2/2, -l1/2, hs), x_size=lside, y_size=-w1)
  Rectangle168 = rectangle(corner=(l2/2, l1/2, hs), x_size=lside, y_size=w1)
  Rectangle163.unite(Rectangle165..Rectangle168)
  Rectangle163.move(19.136mm, 0mm, 0mm)
  Rectangle157.unite(Rectangle163)
  Rectangle157.move(19.136mm, -6.197mm, 0mm)
  Rectangle157.move(74.772mm, -8.8817842e-16mm, 0mm)
  Rectangle157.move(46.954mm, -9.002mm, 0mm)
  Rectangle157.move(46.954mm, 9.002mm, 0mm)
  Rectangle169 = rectangle(corner=(186.434mm, 8.107mm, hs), x_size=-w1, y_size=9.002mm)
  Rectangle169.move(20.168mm, -27.109mm, -0.635mm)
  Rectangle169.move(-79.649mm, 36.111mm, 0.635mm)
  Rectangle169.move(46.954mm, -19.606mm, 0mm)
  Rectangle170 = rectangle(corner=(-l2/2, -(l1+2*w2)/2, hs), x_size=l2, y_size=(l1+2*w2))
  Rectangle171 = rectangle(corner=(-(l2-2*w1)/2, -l1/2, hs), x_size=l2-2*w1, y_size=l1)
  Rectangle170.subtract(Rectangle171)
  Rectangle172 = rectangle(corner=(-l2/2, l1/2, hs), x_size=-lside, y_size=w1)
  Rectangle173 = rectangle(corner=(-l2/2, -l1/2, hs), x_size=-lside, y_size=-w1)
  Rectangle174 = rectangle(corner=(l2/2, -l1/2, hs), x_size=lside, y_size=-w1)
  Rectangle175 = rectangle(corner=(l2/2, l1/2, hs), x_size=lside, y_size=w1)
  Rectangle170.unite(Rectangle172..Rectangle175)
  Rectangle170.move(-8.682mm, 2.805mm, 0mm)
  Rectangle170.move(74.772mm, -4.4408921e-16mm, 0mm)
  Rectangle170.move(193.734mm, 9.002mm, -3.4194869e-14mm)
  Rectangle176 = rectangle(corner=(186.434mm, 8.107mm, 0.635mm), x_size=-w1, y_size=9.002mm)
  Rectangle176.move(20.168mm, -27.109mm, -0.635mm)
  Rectangle176.move(-79.649mm, 36.111mm, 0.635mm)
  Rectangle176.move(46.954mm, -19.606mm, 0mm)
  Rectangle176.move(72.008mm, 1.602mm, -3.4083847e-14mm)
  Rectangle177 = rectangle(corner=(220.861mm, -2.497mm, 0.635mm), x_size=25.054mm, y_size=1.602mm)
  Rectangle178 = rectangle(corner=(l2/2, l1/2, hs), x_size=lside, y_size=w1)
  Rectangle179 = rectangle(corner=(-l2/2, -(l1+2*w2)/2, hs), x_size=l2, y_size=(l1+2*w2))
  Rectangle180 = rectangle(corner=(-(l2-2*w1)/2, -l1/2, hs), x_size=l2-2*w1, y_size=l1)
  Rectangle179.subtract(Rectangle180)
  Rectangle181 = rectangle(corner=(-l2/2, -l1/2, hs), x_size=-lside, y_size=-w1)
  Rectangle178.unite(Rectangle179, Rectangle181)
  Rectangle182 = rectangle(corner=(l2/2, -l1/2, hs), x_size=lside, y_size=-w1)
  Rectangle184 = rectangle(corner=(l2/2, l1/2, hs), x_size=lside, y_size=w1)
  Rectangle185 = rectangle(corner=(-l2/2, -(l1+2*w2)/2, hs), x_size=l2, y_size=(l1+2*w2))
  Rectangle186 = rectangle(corner=(-(l2-2*w1)/2, -l1/2, hs), x_size=l2-2*w1, y_size=l1)
  Rectangle185.subtract(Rectangle186)
  Rectangle187 = rectangle(corner=(-l2/2, -l1/2, hs), x_size=-lside, y_size=-w1)
  Rectangle184.unite(Rectangle185, Rectangle187)
  Rectangle184.move(19.136mm, 0mm, 0mm)
  Rectangle183 = rectangle(corner=(l2/2, l1/2, hs), x_size=lside, y_size=w1)
  Rectangle183.move(5.93mm, 0mm, 0mm)
  Rectangle178.unite(Rectangle182, Rectangle184, Rectangle183)
  Rectangle178.move(19.136mm, 11.807mm, 0mm)
  Rectangle178.move(74.772mm, 8.8817842e-16mm, 0mm)
  Rectangle178.move(60.001mm, 3.495mm, -0.635mm)
  Rectangle178.rotate(axis=Y, angle=180deg)
  Rectangle178.move(246.954mm, -49.002mm, 0mm)
  Rectangle178.move(79.48mm, 45.507mm, 0.635mm)
  Rectangle178.move(-30mm, -60mm, 0mm)
  Rectangle178.move(-104.253mm, 23.992mm, 2.2870594e-14mm)
  Rectangle188 = rectangle(corner=(220.861mm, -2.497mm, hs), x_size=25.054mm, y_size=w1)
  Rectangle188.move(5.6843419e-14mm, -9.002mm, 0mm)
  Rectangle189 = rectangle(corner=(186.434mm, 8.107mm, 0.635mm), x_size=-w1, y_size=9.002mm)
  Rectangle189.move(20.168mm, -27.109mm, -0.635mm)
  Rectangle189.move(-79.649mm, 36.111mm, 0.635mm)
  Rectangle189.move(46.954mm, -19.606mm, 0mm)
  Rectangle189.move(72.008mm, 1.602mm, -3.4083847e-14mm)
  Rectangle189.move(0mm, -19.606mm, 3.4083847e-14mm)
  Rectangle189_1 = Rectangle189.duplicate_along_line(step=(29.42mm, -3.5527137e-15mm, 0mm), total=2)
  Rectangle190 = rectangle(corner=(-l2/2, -(l1+2*w2)/2, hs), x_size=l2, y_size=(l1+2*w2))
  Rectangle191 = rectangle(corner=(-(l2-2*w1)/2, -l1/2, hs), x_size=l2-2*w1, y_size=l1)
  Rectangle190.subtract(Rectangle191)
  Rectangle192 = rectangle(corner=(-l2/2, l1/2, hs), x_size=-lside, y_size=w1)
  Rectangle193 = rectangle(corner=(-l2/2, -l1/2, hs), x_size=-lside, y_size=-w1)
  Rectangle194 = rectangle(corner=(l2/2, -l1/2, hs), x_size=lside, y_size=-w1)
  Rectangle195 = rectangle(corner=(l2/2, l1/2, hs), x_size=lside, y_size=w1)
  Rectangle190.unite(Rectangle192..Rectangle195)
  Rectangle190.move(-8.682mm, 2.805mm, 0mm)
  Rectangle190.move(74.772mm, -4.4408921e-16mm, 0mm)
  Rectangle190.move(193.734mm, 9.002mm, -3.4194869e-14mm)
  Rectangle190.move(0mm, -36.008mm, 3.4083847e-14mm)
  Rectangle196 = rectangle(corner=(-l2/2, -(l1+2*w2)/2, hs), x_size=l2, y_size=(l1+2*w2))
  Rectangle197 = rectangle(corner=(-(l2-2*w1)/2, -l1/2, hs), x_size=l2-2*w1, y_size=l1)
  Rectangle196.subtract(Rectangle197)
  Rectangle198 = rectangle(corner=(-l2/2, l1/2, hs), x_size=-lside, y_size=w1)
  Rectangle199 = rectangle(corner=(-l2/2, -l1/2, hs), x_size=-lside, y_size=-w1)
  Rectangle200 = rectangle(corner=(l2/2, -l1/2, hs), x_size=lside, y_size=-w1)
  Rectangle201 = rectangle(corner=(l2/2, l1/2, hs), x_size=lside, y_size=w1)
  Rectangle196.unite(Rectangle198..Rectangle201)
  Rectangle202 = rectangle(corner=(-l2/2, -(l1+2*w2)/2, hs), x_size=l2, y_size=(l1+2*w2))
  Rectangle203 = rectangle(corner=(-(l2-2*w1)/2, -l1/2, hs), x_size=l2-2*w1, y_size=l1)
  Rectangle202.subtract(Rectangle203)
  Rectangle204 = rectangle(corner=(-l2/2, l1/2, hs), x_size=-lside, y_size=w1)
  Rectangle205 = rectangle(corner=(-l2/2, -l1/2, hs), x_size=-lside, y_size=-w1)
  Rectangle206 = rectangle(corner=(l2/2, -l1/2, hs), x_size=lside, y_size=-w1)
  Rectangle207 = rectangle(corner=(l2/2, l1/2, hs), x_size=lside, y_size=w1)
  Rectangle202.unite(Rectangle204..Rectangle207)
  Rectangle202.move(19.136mm, 0mm, 0mm)
  Rectangle196.unite(Rectangle202)
  Rectangle196.move(19.136mm, -6.197mm, 0mm)
  Rectangle196.move(74.772mm, -8.8817842e-16mm, 0mm)
  Rectangle196.move(46.954mm, -9.002mm, 0mm)
  Rectangle196.move(72.008mm, -18.004mm, 0mm)
  Rectangle208 = rectangle(corner=(186.434mm, 8.107mm, hs), x_size=-w1, y_size=9.002mm)
  Rectangle208.move(20.168mm, -27.109mm, -0.635mm)
  Rectangle208.move(-79.649mm, 36.111mm, 0.635mm)
  Rectangle208.move(46.954mm, -19.606mm, 0mm)
  Rectangle208.move(72.008mm, 1.602mm, -3.4083847e-14mm)
  Rectangle208.move(0mm, -19.606mm, 3.4083847e-14mm)
  Rectangle208.move(-70.406mm, -7.4mm, 0mm)
  Rectangle209 = rectangle(corner=(198.961mm, -27.901mm, hs), x_size=-25.054mm, y_size=-w1)
  Rectangle210 = rectangle(corner=(-l2/2, -(l1+2*w2)/2, hs), x_size=l2, y_size=(l1+2*w2))
  Rectangle211 = rectangle(corner=(-(l2-2*w1)/2, -l1/2, hs), x_size=l2-2*w1, y_size=l1)
  Rectangle210.subtract(Rectangle211)
  Rectangle212 = rectangle(corner=(-l2/2, l1/2, hs), x_size=-lside, y_size=w1)
  Rectangle213 = rectangle(corner=(-l2/2, -l1/2, hs), x_size=-lside, y_size=-w1)
  Rectangle214 = rectangle(corner=(l2/2, -l1/2, hs), x_size=lside, y_size=-w1)
  Rectangle215 = rectangle(corner=(l2/2, l1/2, hs), x_size=lside, y_size=w1)
  Rectangle210.unite(Rectangle212..Rectangle215)
  Rectangle216 = rectangle(corner=(-l2/2, -(l1+2*w2)/2, hs), x_size=l2, y_size=(l1+2*w2))
  Rectangle217 = rectangle(corner=(-(l2-2*w1)/2, -l1/2, hs), x_size=l2-2*w1, y_size=l1)
  Rectangle216.subtract(Rectangle217)
  Rectangle218 = rectangle(corner=(-l2/2, l1/2, hs), x_size=-lside, y_size=w1)
  Rectangle219 = rectangle(corner=(-l2/2, -l1/2, hs), x_size=-lside, y_size=-w1)
  Rectangle220 = rectangle(corner=(l2/2, -l1/2, hs), x_size=lside, y_size=-w1)
  Rectangle221 = rectangle(corner=(l2/2, l1/2, hs), x_size=lside, y_size=w1)
  Rectangle216.unite(Rectangle218..Rectangle221)
  Rectangle216.move(19.136mm, 0mm, 0mm)
  Rectangle210.unite(Rectangle216)
  Rectangle210.move(19.136mm, -6.197mm, 0mm)
  Rectangle210.move(74.772mm, -8.8817842e-16mm, 0mm)
  Rectangle210.move(46.954mm, -9.002mm, 0mm)
  Rectangle210.move(72.008mm, -18.004mm, 0mm)
  Rectangle210.move(-46.954mm, -9.002mm, 0mm)
  Rectangle210.move(0mm, -9.002mm, 0mm)
  Rectangle223 = rectangle(corner=(198.961mm, -27.901mm, hs), x_size=-25.054mm, y_size=-w1)
  Rectangle223.move(-46.954mm, -9.002mm, -1.6986412e-14mm)
  Rectangle223.move(-8.5265128e-14mm, -9.002mm, 1.6986412e-14mm)
  Rectangle231 = rectangle(corner=(186.434mm, 8.107mm, hs), x_size=-w1, y_size=9.002mm)
  Rectangle231.move(20.168mm, -27.109mm, -0.635mm)
  Rectangle231.move(-79.649mm, 36.111mm, 0.635mm)
  Rectangle231.move(46.954mm, -19.606mm, 0mm)
  Rectangle231.move(72.008mm, 1.602mm, -3.4083847e-14mm)
  Rectangle231.move(0mm, -19.606mm, 3.4083847e-14mm)
  Rectangle231.move(-70.406mm, -7.4mm, 0mm)
  Rectangle231.move(-46.954mm, -9.002mm, -1.6986412e-14mm)
  Rectangle231.move(72.008mm, -10.604mm, 0mm)
  Rectangle233 = rectangle(corner=(126.953mm, -27.901mm, hs), x_size=w1, y_size=-18.099mm)
  Rectangle233.move(-48.556mm, 0mm, 0mm)
  Rectangle234 = rectangle(corner=(-l2/2, -(l1+2*w2)/2, hs), x_size=l2, y_size=(l1+2*w2))
  Rectangle235 = rectangle(corner=(-(l2-2*w1)/2, -l1/2, hs), x_size=l2-2*w1, y_size=l1)
  Rectangle234.subtract(Rectangle235)
  Rectangle236 = rectangle(corner=(-l2/2, l1/2, hs), x_size=-lside, y_size=w1)
  Rectangle237 = rectangle(corner=(-l2/2, -l1/2, hs), x_size=-lside, y_size=-w1)
  Rectangle238 = rectangle(corner=(l2/2, -l1/2, hs), x_size=lside, y_size=-w1)
  Rectangle239 = rectangle(corner=(l2/2, l1/2, hs), x_size=lside, y_size=w1)
  Rectangle234.unite(Rectangle236..Rectangle239)
  Rectangle234.move(-8.682mm, 2.805mm, 0mm)
  Rectangle234.move(74.772mm, -4.4408921e-16mm, 0mm)
  Rectangle234.move(1.4210855e-14mm, -18.004mm, 0mm)
  Rectangle234.move(0mm, -36.103mm, 0mm)
  Rectangle240 = rectangle(corner=(52.181mm, 6.505mm, hs), x_size=-w1, y_size=9.002mm)
  Rectangle240.move(1.4210855e-14mm, -54.107mm, 0mm)
  Rectangle241 = rectangle(corner=(l2/2, l1/2, hs), x_size=lside, y_size=w1)
  Rectangle242 = rectangle(corner=(-l2/2, -(l1+2*w2)/2, hs), x_size=l2, y_size=(l1+2*w2))
  Rectangle243 = rectangle(corner=(-(l2-2*w1)/2, -l1/2, hs), x_size=l2-2*w1, y_size=l1)
  Rectangle242.subtract(Rectangle243)
  Rectangle244 = rectangle(corner=(-l2/2, -l1/2, hs), x_size=-lside, y_size=-w1)
  Rectangle241.unite(Rectangle242, Rectangle244)
  Rectangle245 = rectangle(corner=(l2/2, -l1/2, hs), x_size=lside, y_size=-w1)
  Rectangle247 = rectangle(corner=(l2/2, l1/2, hs), x_size=lside, y_size=w1)
  Rectangle248 = rectangle(corner=(-l2/2, -(l1+2*w2)/2, hs), x_size=l2, y_size=(l1+2*w2))
  Rectangle249 = rectangle(corner=(-(l2-2*w1)/2, -l1/2, hs), x_size=l2-2*w1, y_size=l1)
  Rectangle248.subtract(Rectangle249)
  Rectangle250 = rectangle(corner=(-l2/2, -l1/2, hs), x_size=-lside, y_size=-w1)
  Rectangle247.unite(Rectangle248, Rectangle250)
  Rectangle247.move(19.136mm, 0mm, 0mm)
  Rectangle246 = rectangle(corner=(l2/2, l1/2, hs), x_size=lside, y_size=w1)
  Rectangle246.move(5.93mm, 0mm, 0mm)
  Rectangle241.unite(Rectangle245, Rectangle247, Rectangle246)
  Rectangle241.move(19.136mm, 11.807mm, 0mm)
  Rectangle241.move(1.4210855e-14mm, -54.107mm, 0mm)
  Rectangle251 = rectangle(corner=(-l2/2, -(l1+2*w2)/2, hs), x_size=l2, y_size=(l1+2*w2))
  Rectangle252 = rectangle(corner=(-(l2-2*w1)/2, -l1/2, hs), x_size=l2-2*w1, y_size=l1)
  Rectangle251.subtract(Rectangle252)
  Rectangle253 = rectangle(corner=(-l2/2, l1/2, hs), x_size=-lside, y_size=w1)
  Rectangle254 = rectangle(corner=(-l2/2, -l1/2, hs), x_size=-lside, y_size=-w1)
  Rectangle255 = rectangle(corner=(l2/2, -l1/2, hs), x_size=lside, y_size=-w1)
  Rectangle256 = rectangle(corner=(l2/2, l1/2, hs), x_size=lside, y_size=w1)
  Rectangle251.unite(Rectangle253..Rectangle256)
  Rectangle251.move(-8.682mm, 2.805mm, 0mm)
  Rectangle251.move(1.0658141e-14mm, -54.107mm, 0mm)
  Rectangle257 = rectangle(corner=(-l2/2, -(l1+2*w2)/2, hs), x_size=l2, y_size=(l1+2*w2))
  Rectangle258 = rectangle(corner=(-(l2-2*w1)/2, -l1/2, hs), x_size=l2-2*w1, y_size=l1)
  Rectangle257.subtract(Rectangle258)
  Rectangle259 = rectangle(corner=(-l2/2, l1/2, hs), x_size=-lside, y_size=w1)
  Rectangle260 = rectangle(corner=(-l2/2, -l1/2, hs), x_size=-lside, y_size=-w1)
  Rectangle261 = rectangle(corner=(l2/2, -l1/2, hs), x_size=lside, y_size=-w1)
  Rectangle262 = rectangle(corner=(l2/2, l1/2, hs), x_size=lside, y_size=w1)
  Rectangle257.unite(Rectangle259..Rectangle262)
  Rectangle263 = rectangle(corner=(-l2/2, -(l1+2*w2)/2, hs), x_size=l2, y_size=(l1+2*w2))
  Rectangle264 = rectangle(corner=(-(l2-2*w1)/2, -l1/2, hs), x_size=l2-2*w1, y_size=l1)
  Rectangle263.subtract(Rectangle264)
  Rectangle265 = rectangle(corner=(-l2/2, l1/2, hs), x_size=-lside, y_size=w1)
  Rectangle266 = rectangle(corner=(-l2/2, -l1/2, hs), x_size=-lside, y_size=-w1)
  Rectangle267 = rectangle(corner=(l2/2, -l1/2, hs), x_size=lside, y_size=-w1)
  Rectangle268 = rectangle(corner=(l2/2, l1/2, hs), x_size=lside, y_size=w1)
  Rectangle263.unite(Rectangle265..Rectangle268)
  Rectangle263.move(19.136mm, 0mm, 0mm)
  Rectangle257.unite(Rectangle263)
  Rectangle257.move(19.136mm, -6.197mm, 0mm)
  Rectangle257.move(1.2434498e-14mm, -54.107mm, 0mm)
  Rectangle269 = rectangle(corner=(-l2/2, -(l1+2*w2)/2, hs), x_size=l2, y_size=(l1+2*w2))
  Rectangle270 = rectangle(corner=(-(l2-2*w1)/2, -l1/2, hs), x_size=l2-2*w1, y_size=l1)
  Rectangle269.subtract(Rectangle270)
  Rectangle271 = rectangle(corner=(-l2/2, l1/2, hs), x_size=-lside, y_size=w1)
  Rectangle272 = rectangle(corner=(-l2/2, -l1/2, hs), x_size=-lside, y_size=-w1)
  Rectangle273 = rectangle(corner=(l2/2, -l1/2, hs), x_size=lside, y_size=-w1)
  Rectangle274 = rectangle(corner=(l2/2, l1/2, hs), x_size=lside, y_size=w1)
  Rectangle269.unite(Rectangle271..Rectangle274)
  Rectangle269.move(-8.682mm, 2.805mm, 0mm)
  Rectangle269.move(0mm, -18.004mm, 0mm)
  Rectangle269.move(9.7699626e-15mm, -54.107mm, 0mm)
  Rectangle275 = rectangle(corner=(-l2/2, -(l1+2*w2)/2, hs), x_size=l2, y_size=(l1+2*w2))
  Rectangle276 = rectangle(corner=(-(l2-2*w1)/2, -l1/2, hs), x_size=l2-2*w1, y_size=l1)
  Rectangle275.subtract(Rectangle276)
  Rectangle277 = rectangle(corner=(-l2/2, l1/2, hs), x_size=-lside, y_size=w1)
  Rectangle278 = rectangle(corner=(-l2/2, -l1/2, hs), x_size=-lside, y_size=-w1)
  Rectangle279 = rectangle(corner=(l2/2, -l1/2, hs), x_size=lside, y_size=-w1)
  Rectangle280 = rectangle(corner=(l2/2, l1/2, hs), x_size=lside, y_size=w1)
  Rectangle275.unite(Rectangle277..Rectangle280)
  Rectangle275.move(-8.682mm, 2.805mm, 0mm)
  Rectangle275.move(74.772mm, -4.4408921e-16mm, 0mm)
  Rectangle275.move(1.4210855e-14mm, -18.004mm, 0mm)
  Rectangle275.move(0mm, -36.103mm, 0mm)
  Rectangle275.move(0mm, -18.004mm, 0mm)
  Rectangle281 = rectangle(corner=(l2/2, l1/2, hs), x_size=lside, y_size=w1)
  Rectangle282 = rectangle(corner=(-l2/2, -(l1+2*w2)/2, hs), x_size=l2, y_size=(l1+2*w2))
  Rectangle283 = rectangle(corner=(-(l2-2*w1)/2, -l1/2, hs), x_size=l2-2*w1, y_size=l1)
  Rectangle282.subtract(Rectangle283)
  Rectangle284 = rectangle(corner=(-l2/2, -l1/2, hs), x_size=-lside, y_size=-w1)
  Rectangle281.unite(Rectangle282, Rectangle284)
  Rectangle285 = rectangle(corner=(l2/2, -l1/2, hs), x_size=lside, y_size=-w1)
  Rectangle287 = rectangle(corner=(l2/2, l1/2, hs), x_size=lside, y_size=w1)
  Rectangle288 = rectangle(corner=(-l2/2, -(l1+2*w2)/2, hs), x_size=l2, y_size=(l1+2*w2))
  Rectangle289 = rectangle(corner=(-(l2-2*w1)/2, -l1/2, hs), x_size=l2-2*w1, y_size=l1)
  Rectangle288.subtract(Rectangle289)
  Rectangle290 = rectangle(corner=(-l2/2, -l1/2, hs), x_size=-lside, y_size=-w1)
  Rectangle287.unite(Rectangle288, Rectangle290)
  Rectangle287.move(19.136mm, 0mm, 0mm)
  Rectangle286 = rectangle(corner=(l2/2, l1/2, hs), x_size=lside, y_size=w1)
  Rectangle286.move(5.93mm, 0mm, 0mm)
  Rectangle281.unite(Rectangle285, Rectangle287, Rectangle286)
  Rectangle281.move(19.136mm, 11.807mm, 0mm)
  Rectangle281.move(74.772mm, 8.8817842e-16mm, 0mm)
  Rectangle281.move(60.001mm, 3.495mm, -0.635mm)
  Rectangle281.rotate(axis=Y, angle=180deg)
  Rectangle281.move(246.954mm, -49.002mm, 0mm)
  Rectangle281.move(79.48mm, 45.507mm, 0.635mm)
  Rectangle281.move(-30mm, -60mm, 0mm)
  Rectangle281.move(-104.253mm, 23.992mm, 2.2870594e-14mm)
  Rectangle281.move(7.1054274e-15mm, -54.107mm, 0mm)
  Rectangle291 = rectangle(corner=(52.181mm, 6.505mm, hs), x_size=-w1, y_size=9.002mm)
  Rectangle291.move(-46.954mm, -36.008mm, 0mm)
  Rectangle291.move(48.556mm, 0mm, 0mm)
  Rectangle291.move(4.9737992e-14mm, -54.107mm, 5.7731597e-15mm)
  Rectangle292 = rectangle(corner=(-l2/2, -(l1+2*w2)/2, hs), x_size=l2, y_size=(l1+2*w2))
  Rectangle293 = rectangle(corner=(-(l2-2*w1)/2, -l1/2, hs), x_size=l2-2*w1, y_size=l1)
  Rectangle292.subtract(Rectangle293)
  Rectangle294 = rectangle(corner=(-l2/2, l1/2, hs), x_size=-lside, y_size=w1)
  Rectangle295 = rectangle(corner=(-l2/2, -l1/2, hs), x_size=-lside, y_size=-w1)
  Rectangle296 = rectangle(corner=(l2/2, -l1/2, hs), x_size=lside, y_size=-w1)
  Rectangle297 = rectangle(corner=(l2/2, l1/2, hs), x_size=lside, y_size=w1)
  Rectangle292.unite(Rectangle294..Rectangle297)
  Rectangle298 = rectangle(corner=(-l2/2, -(l1+2*w2)/2, hs), x_size=l2, y_size=(l1+2*w2))
  Rectangle299 = rectangle(corner=(-(l2-2*w1)/2, -l1/2, hs), x_size=l2-2*w1, y_size=l1)
  Rectangle298.subtract(Rectangle299)
  Rectangle300 = rectangle(corner=(-l2/2, l1/2, hs), x_size=-lside, y_size=w1)
  Rectangle301 = rectangle(corner=(-l2/2, -l1/2, hs), x_size=-lside, y_size=-w1)
  Rectangle302 = rectangle(corner=(l2/2, -l1/2, hs), x_size=lside, y_size=-w1)
  Rectangle303 = rectangle(corner=(l2/2, l1/2, hs), x_size=lside, y_size=w1)
  Rectangle298.unite(Rectangle300..Rectangle303)
  Rectangle298.move(19.136mm, 0mm, 0mm)
  Rectangle292.unite(Rectangle298)
  Rectangle292.move(19.136mm, -6.197mm, 0mm)
  Rectangle292.move(74.772mm, -8.8817842e-16mm, 0mm)
  Rectangle292.move(2.8421709e-14mm, -54.107mm, 0mm)
  Rectangle304 = rectangle(corner=(l2/2, l1/2, hs), x_size=lside, y_size=w1)
  Rectangle305 = rectangle(corner=(-l2/2, -(l1+2*w2)/2, hs), x_size=l2, y_size=(l1+2*w2))
  Rectangle306 = rectangle(corner=(-(l2-2*w1)/2, -l1/2, hs), x_size=l2-2*w1, y_size=l1)
  Rectangle305.subtract(Rectangle306)
  Rectangle307 = rectangle(corner=(-l2/2, -l1/2, hs), x_size=-lside, y_size=-w1)
  Rectangle304.unite(Rectangle305, Rectangle307)
  Rectangle308 = rectangle(corner=(l2/2, -l1/2, hs), x_size=lside, y_size=-w1)
  Rectangle310 = rectangle(corner=(l2/2, l1/2, hs), x_size=lside, y_size=w1)
  Rectangle311 = rectangle(corner=(-l2/2, -(l1+2*w2)/2, hs), x_size=l2, y_size=(l1+2*w2))
  Rectangle312 = rectangle(corner=(-(l2-2*w1)/2, -l1/2, hs), x_size=l2-2*w1, y_size=l1)
  Rectangle311.subtract(Rectangle312)
  Rectangle313 = rectangle(corner=(-l2/2, -l1/2, hs), x_size=-lside, y_size=-w1)
  Rectangle310.unite(Rectangle311, Rectangle313)
  Rectangle310.move(19.136mm, 0mm, 0mm)
  Rectangle309 = rectangle(corner=(l2/2, l1/2, hs), x_size=lside, y_size=w1)
  Rectangle309.move(5.93mm, 0mm, 0mm)
  Rectangle304.unite(Rectangle308, Rectangle310, Rectangle309)
  Rectangle304.move(19.136mm, 11.807mm, 0mm)
  Rectangle304.move(74.772mm, 8.8817842e-16mm, 0mm)
  Rectangle304.move(60.001mm, 3.495mm, -0.635mm)
  Rectangle304.rotate(axis=Y, angle=180deg)
  Rectangle304.move(246.954mm, -49.002mm, 0mm)
  Rectangle304.move(79.48mm, 45.507mm, 0.635mm)
  Rectangle304.move(-30mm, -60mm, 0mm)
  Rectangle304.move(-104.253mm, 23.992mm, 2.2870594e-14mm)
  Rectangle304.move(7.1054274e-15mm, -54.107mm, 0mm)
  Rectangle304.move(74.772mm, -2.8421709e-14mm, 0mm)
  Rectangle314 = rectangle(corner=(198.961mm, -27.901mm, hs), x_size=-25.054mm, y_size=-w1)
  Rectangle314.move(-46.954mm, -9.002mm, -1.6986412e-14mm)
  Rectangle314.move(-8.5265128e-14mm, -9.002mm, 1.6986412e-14mm)
  Rectangle314.move(2.8421709e-14mm, -9.002mm, 0mm)
  Rectangle315 = rectangle(corner=(186.434mm, 8.107mm, hs), x_size=-w1, y_size=9.002mm)
  Rectangle315.move(20.168mm, -27.109mm, -0.635mm)
  Rectangle315.move(-79.649mm, 36.111mm, 0.635mm)
  Rectangle315.move(1.602mm, -108.119mm, -1.1213253e-14mm)
  Rectangle315.move(-1.602mm, -1.602mm, -1.110223e-16mm)
  Rectangle316 = rectangle(corner=(l2/2, l1/2, hs), x_size=lside, y_size=w1)
  Rectangle317 = rectangle(corner=(-l2/2, -(l1+2*w2)/2, hs), x_size=l2, y_size=(l1+2*w2))
  Rectangle318 = rectangle(corner=(-(l2-2*w1)/2, -l1/2, hs), x_size=l2-2*w1, y_size=l1)
  Rectangle317.subtract(Rectangle318)
  Rectangle319 = rectangle(corner=(-l2/2, -l1/2, hs), x_size=-lside, y_size=-w1)
  Rectangle316.unite(Rectangle317, Rectangle319)
  Rectangle320 = rectangle(corner=(l2/2, -l1/2, hs), x_size=lside, y_size=-w1)
  Rectangle322 = rectangle(corner=(l2/2, l1/2, hs), x_size=lside, y_size=w1)
  Rectangle323 = rectangle(corner=(-l2/2, -(l1+2*w2)/2, hs), x_size=l2, y_size=(l1+2*w2))
  Rectangle324 = rectangle(corner=(-(l2-2*w1)/2, -l1/2, hs), x_size=l2-2*w1, y_size=l1)
  Rectangle323.subtract(Rectangle324)
  Rectangle325 = rectangle(corner=(-l2/2, -l1/2, hs), x_size=-lside, y_size=-w1)
  Rectangle322.unite(Rectangle323, Rectangle325)
  Rectangle322.move(19.136mm, 0mm, 0mm)
  Rectangle321 = rectangle(corner=(l2/2, l1/2, hs), x_size=lside, y_size=w1)
  Rectangle321.move(5.93mm, 0mm, 0mm)
  Rectangle316.unite(Rectangle320, Rectangle322, Rectangle321)
  Rectangle316.move(19.136mm, 11.807mm, 0mm)
  Rectangle316.move(74.772mm, 8.8817842e-16mm, 0mm)
  Rectangle316.move(60.001mm, 3.495mm, -0.635mm)
  Rectangle316.rotate(axis=Y, angle=180deg)
  Rectangle316.move(246.954mm, -49.002mm, 0mm)
  Rectangle316.move(79.48mm, 45.507mm, 0.635mm)
  Rectangle316.move(-30mm, -60mm, 0mm)
  Rectangle316.move(-104.253mm, 23.992mm, 2.2870594e-14mm)
  Rectangle316.move(121.726mm, -45.105mm, 0mm)
  Rectangle326 = rectangle(corner=(-l2/2, -(l1+2*w2)/2, hs), x_size=l2, y_size=(l1+2*w2))
  Rectangle327 = rectangle(corner=(-(l2-2*w1)/2, -l1/2, hs), x_size=l2-2*w1, y_size=l1)
  Rectangle326.subtract(Rectangle327)
  Rectangle328 = rectangle(corner=(-l2/2, l1/2, hs), x_size=-lside, y_size=w1)
  Rectangle329 = rectangle(corner=(-l2/2, -l1/2, hs), x_size=-lside, y_size=-w1)
  Rectangle330 = rectangle(corner=(l2/2, -l1/2, hs), x_size=lside, y_size=-w1)
  Rectangle331 = rectangle(corner=(l2/2, l1/2, hs), x_size=lside, y_size=w1)
  Rectangle326.unite(Rectangle328..Rectangle331)
  Rectangle332 = rectangle(corner=(-l2/2, -(l1+2*w2)/2, hs), x_size=l2, y_size=(l1+2*w2))
  Rectangle333 = rectangle(corner=(-(l2-2*w1)/2, -l1/2, hs), x_size=l2-2*w1, y_size=l1)
  Rectangle332.subtract(Rectangle333)
  Rectangle334 = rectangle(corner=(-l2/2, l1/2, hs), x_size=-lside, y_size=w1)
  Rectangle335 = rectangle(corner=(-l2/2, -l1/2, hs), x_size=-lside, y_size=-w1)
  Rectangle336 = rectangle(corner=(l2/2, -l1/2, hs), x_size=lside, y_size=-w1)
  Rectangle337 = rectangle(corner=(l2/2, l1/2, hs), x_size=lside, y_size=w1)
  Rectangle332.unite(Rectangle334..Rectangle337)
  Rectangle332.move(19.136mm, 0mm, 0mm)
  Rectangle326.unite(Rectangle332)
  Rectangle326.move(19.136mm, -6.197mm, 0mm)
  Rectangle326.move(74.772mm, -8.8817842e-16mm, 0mm)
  Rectangle326.move(46.954mm, -9.002mm, 0mm)
  Rectangle326.move(72.008mm, -18.004mm, 0mm)
  Rectangle326.move(0mm, -27.006mm, 0mm)
  Rectangle338 = rectangle(corner=(198.961mm, -27.901mm, hs), x_size=-25.054mm, y_size=-w1)
  Rectangle338.move(-46.954mm, -9.002mm, -1.6986412e-14mm)
  Rectangle338.move(-8.5265128e-14mm, -9.002mm, 1.6986412e-14mm)
  Rectangle338.move(2.8421709e-14mm, -9.002mm, 0mm)
  Rectangle338.move(46.954mm, -9.002mm, 0mm)
  Rectangle339 = rectangle(corner=(186.434mm, 8.107mm, hs), x_size=-w1, y_size=9.002mm)
  Rectangle339.move(20.168mm, -27.109mm, -0.635mm)
  Rectangle339.move(-79.649mm, 36.111mm, 0.635mm)
  Rectangle339.move(46.954mm, -19.606mm, 0mm)
  Rectangle339.move(72.008mm, 1.602mm, -3.4083847e-14mm)
  Rectangle339.move(0mm, -19.606mm, 3.4083847e-14mm)
  Rectangle339.move(-70.406mm, -7.4mm, 0mm)
  Rectangle339.move(-46.954mm, -9.002mm, -1.6986412e-14mm)
  Rectangle339.move(72.008mm, -10.604mm, 0mm)
  Rectangle339.move(-25.054mm, -27.006mm, 0mm)
  Rectangle340 = rectangle(corner=(-l2/2, -(l1+2*w2)/2, hs), x_size=l2, y_size=(l1+2*w2))
  Rectangle341 = rectangle(corner=(-(l2-2*w1)/2, -l1/2, hs), x_size=l2-2*w1, y_size=l1)
  Rectangle340.subtract(Rectangle341)
  Rectangle342 = rectangle(corner=(-l2/2, l1/2, hs), x_size=-lside, y_size=w1)
  Rectangle343 = rectangle(corner=(-l2/2, -l1/2, hs), x_size=-lside, y_size=-w1)
  Rectangle344 = rectangle(corner=(l2/2, -l1/2, hs), x_size=lside, y_size=-w1)
  Rectangle345 = rectangle(corner=(l2/2, l1/2, hs), x_size=lside, y_size=w1)
  Rectangle340.unite(Rectangle342..Rectangle345)
  Rectangle340.move(-8.682mm, 2.805mm, 0mm)
  Rectangle340.move(74.772mm, -4.4408921e-16mm, 0mm)
  Rectangle340.move(193.734mm, 9.002mm, -3.4194869e-14mm)
  Rectangle340.move(0mm, -36.008mm, 3.4083847e-14mm)
  Rectangle340.move(0mm, -27.006mm, 0mm)
  Rectangle346 = rectangle(corner=(186.434mm, 8.107mm, 0.635mm), x_size=-w1, y_size=9.002mm)
  Rectangle346.move(20.168mm, -27.109mm, -0.635mm)
  Rectangle346.move(-79.649mm, 36.111mm, 0.635mm)
  Rectangle346.move(46.954mm, -19.606mm, 0mm)
  Rectangle346.move(72.008mm, 1.602mm, -3.4083847e-14mm)
  Rectangle346.move(0mm, -19.606mm, 3.4083847e-14mm)
  Rectangle346.move(0mm, -27.006mm, 0mm)
  Rectangle347 = rectangle(corner=(-l2/2, -(l1+2*w2)/2, hs), x_size=l2, y_size=(l1+2*w2))
  Rectangle348 = rectangle(corner=(-(l2-2*w1)/2, -l1/2, hs), x_size=l2-2*w1, y_size=l1)
  Rectangle347.subtract(Rectangle348)
  Rectangle349 = rectangle(corner=(-l2/2, l1/2, hs), x_size=-lside, y_size=w1)
  Rectangle350 = rectangle(corner=(-l2/2, -l1/2, hs), x_size=-lside, y_size=-w1)
  Rectangle351 = rectangle(corner=(l2/2, -l1/2, hs), x_size=lside, y_size=-w1)
  Rectangle352 = rectangle(corner=(l2/2, l1/2, hs), x_size=lside, y_size=w1)
  Rectangle347.unite(Rectangle349..Rectangle352)
  Rectangle347.move(-8.682mm, 2.805mm, 0mm)
  Rectangle347.move(74.772mm, -4.4408921e-16mm, 0mm)
  Rectangle347.move(193.734mm, 9.002mm, -3.4194869e-14mm)
  Rectangle347.move(0mm, -36.008mm, 3.4083847e-14mm)
  Rectangle347.move(0mm, -27.006mm, 0mm)
  Rectangle347.move(0mm, -18.004mm, 0mm)
  Rectangle347.move(8.5265128e-14mm, -9.097mm, -2.8421709e-14mm)
  Rectangle355 = rectangle(corner=(245.915mm, -74.608mm, hs), x_size=-w1, y_size=9.108mm)
  Rectangle356 = rectangle(corner=(126.953mm, -27.901mm, hs), x_size=w1, y_size=-18.004mm)
  Rectangle359 = rectangle(corner=(-l2/2, -(l1+2*w2)/2, hs), x_size=l2, y_size=(l1+2*w2))
  Rectangle360 = rectangle(corner=(-(l2-2*w1)/2, -l1/2, hs), x_size=l2-2*w1, y_size=l1)
  Rectangle359.subtract(Rectangle360)
  Rectangle361 = rectangle(corner=(-l2/2, l1/2, hs), x_size=-lside, y_size=w1)
  Rectangle362 = rectangle(corner=(-l2/2, -l1/2, hs), x_size=-lside, y_size=-w1)
  Rectangle363 = rectangle(corner=(l2/2, -l1/2, hs), x_size=lside, y_size=-w1)
  Rectangle364 = rectangle(corner=(l2/2, l1/2, hs), x_size=lside, y_size=w1)
  Rectangle359.unite(Rectangle361..Rectangle364)
  Rectangle359.move(-8.682mm, 2.805mm, 0mm)
  Rectangle359.move(0mm, -18.004mm, 0mm)
  Rectangle359.move(0mm, 18.004mm, 0mm)
  Rectangle365 = rectangle(corner=(-lhori/2, -lshift/2, hs), x_size=-3.86mm, y_size=w1)
  Rectangle365.move(7.16mm, 0mm, 0mm)
  Rectangle365.move(1.507mm, 0mm, 0mm)
  Rectangle365.move(133.2165mm, 29.509mm, 0.079mm)
  Rectangle366 = rectangle(corner=(-lhori/2, -lshift/2, hs), x_size=lhori, y_size=lshift)
  Rectangle367 = rectangle(corner=(-lhori/2+w1, -lshift/2, hs), x_size=lhori-2*w1, y_size=lshift-w1)
  Rectangle366.subtract(Rectangle367)
  Rectangle366.move(133.2165mm, 29.509mm, 0.079mm)
  Rectangle365.unite(Rectangle366)
  Rectangle365.mirror(point=(134.018mm, 24.509mm, 0.714mm), normal=(0mm, -1mm, 0mm))
  Rectangle365.move(5.6843419e-14mm, -115.519mm, -0.079mm)
  Rectangle409 = rectangle(corner=(l2/2, l1/2, hs), x_size=lside, y_size=w1)
  Rectangle410 = rectangle(corner=(-l2/2, -(l1+2*w2)/2, hs), x_size=l2, y_size=(l1+2*w2))
  Rectangle411 = rectangle(corner=(-(l2-2*w1)/2, -l1/2, hs), x_size=l2-2*w1, y_size=l1)
  Rectangle410.subtract(Rectangle411)
  Rectangle412 = rectangle(corner=(-l2/2, -l1/2, hs), x_size=-lside, y_size=-w1)
  Rectangle409.unite(Rectangle410, Rectangle412)
  Rectangle413 = rectangle(corner=(l2/2, -l1/2, hs), x_size=lside, y_size=-w1)
  Rectangle415 = rectangle(corner=(l2/2, l1/2, hs), x_size=lside, y_size=w1)
  Rectangle416 = rectangle(corner=(-l2/2, -(l1+2*w2)/2, hs), x_size=l2, y_size=(l1+2*w2))
  Rectangle417 = rectangle(corner=(-(l2-2*w1)/2, -l1/2, hs), x_size=l2-2*w1, y_size=l1)
  Rectangle416.subtract(Rectangle417)
  Rectangle418 = rectangle(corner=(-l2/2, -l1/2, hs), x_size=-lside, y_size=-w1)
  Rectangle415.unite(Rectangle416, Rectangle418)
  Rectangle415.move(19.136mm, 0mm, 0mm)
  Rectangle414 = rectangle(corner=(l2/2, l1/2, hs), x_size=lside, y_size=w1)
  Rectangle414.move(5.93mm, 0mm, 0mm)
  Rectangle409.unite(Rectangle413, Rectangle415, Rectangle414)
  Rectangle409.move(19.136mm, 11.807mm, 0mm)
  Rectangle409.move(74.772mm, 8.8817842e-16mm, 0mm)
  Rectangle409.move(46.954mm, -9.002mm, 0mm)
  Rectangle409.move(12.527mm, -90.115mm, 5.884182e-15mm)
  Rectangle419 = rectangle(corner=(186.434mm, 8.107mm, hs), x_size=-w1, y_size=9.002mm)
  Rectangle419.move(20.168mm, -27.109mm, -0.635mm)
  Rectangle419.move(-79.649mm, 36.111mm, 0.635mm)
  Rectangle419.move(1.602mm, -108.119mm, -1.1213253e-14mm)
  Rectangle419.move(-1.602mm, -1.602mm, -1.110223e-16mm)
  Rectangle419.move(59.481mm, -4.2632564e-14mm, 1.110223e-16mm)
  Rectangle421 = rectangle(corner=(-lhori/2, -lshift/2, hs), x_size=-3.86mm, y_size=w1)
  Rectangle421.move(7.16mm, 0mm, 0mm)
  Rectangle421.move(1.507mm, 0mm, 0mm)
  Rectangle421.move(133.2165mm, 29.509mm, 0.079mm)
  Rectangle422 = rectangle(corner=(-lhori/2, -lshift/2, hs), x_size=lhori, y_size=lshift)
  Rectangle423 = rectangle(corner=(-lhori/2+w1, -lshift/2, hs), x_size=lhori-2*w1, y_size=lshift-w1)
  Rectangle422.subtract(Rectangle423)
  Rectangle422.move(133.2165mm, 29.509mm, 0.079mm)
  Rectangle421.unite(Rectangle422)
  Rectangle421.mirror(point=(134.018mm, 24.509mm, 0.714mm), normal=(0mm, -1mm, 0mm))
  Rectangle421.move(5.6843419e-14mm, -115.519mm, -0.079mm)
  Rectangle421.move(59.437mm, 0mm, 0mm)
  Rectangle421.move(0.025mm, 0.015mm, -5.884182e-15mm)
  Rectangle424 = rectangle(corner=(l2/2, l1/2, hs), x_size=lside, y_size=w1)
  Rectangle425 = rectangle(corner=(-l2/2, -(l1+2*w2)/2, hs), x_size=l2, y_size=(l1+2*w2))
  Rectangle426 = rectangle(corner=(-(l2-2*w1)/2, -l1/2, hs), x_size=l2-2*w1, y_size=l1)
  Rectangle425.subtract(Rectangle426)
  Rectangle427 = rectangle(corner=(-l2/2, -l1/2, hs), x_size=-lside, y_size=-w1)
  Rectangle424.unite(Rectangle425, Rectangle427)
  Rectangle428 = rectangle(corner=(l2/2, -l1/2, hs), x_size=lside, y_size=-w1)
  Rectangle430 = rectangle(corner=(l2/2, l1/2, hs), x_size=lside, y_size=w1)
  Rectangle431 = rectangle(corner=(-l2/2, -(l1+2*w2)/2, hs), x_size=l2, y_size=(l1+2*w2))
  Rectangle432 = rectangle(corner=(-(l2-2*w1)/2, -l1/2, hs), x_size=l2-2*w1, y_size=l1)
  Rectangle431.subtract(Rectangle432)
  Rectangle433 = rectangle(corner=(-l2/2, -l1/2, hs), x_size=-lside, y_size=-w1)
  Rectangle430.unite(Rectangle431, Rectangle433)
  Rectangle430.move(19.136mm, 0mm, 0mm)
  Rectangle429 = rectangle(corner=(l2/2, l1/2, hs), x_size=lside, y_size=w1)
  Rectangle429.move(5.93mm, 0mm, 0mm)
  Rectangle424.unite(Rectangle428, Rectangle430, Rectangle429)
  Rectangle424.move(19.136mm, 11.807mm, 0mm)
  Rectangle424.move(74.772mm, 8.8817842e-16mm, 0mm)
  Rectangle424.move(46.954mm, -9.002mm, 0mm)
  Rectangle424.move(12.527mm, -90.115mm, 5.884182e-15mm)
  Rectangle424.move(59.462mm, 0.015mm, -5.884182e-15mm)
  Rectangle434 = rectangle(corner=(190.275mm, -90.995mm, 0.635mm), x_size=-3.841mm, y_size=-w1)
  Rectangle3 = rectangle(corner=(-lhori/2, -lshift/2, hs), x_size=-3.86mm, y_size=w1)
  Rectangle1 = rectangle(corner=(-lhori/2, -lshift/2, hs), x_size=lhori, y_size=lshift)
  Rectangle2 = rectangle(corner=(-lhori/2+w1, -lshift/2, hs), x_size=lhori-2*w1, y_size=lshift-w1)
  Rectangle1.subtract(Rectangle2)
  Rectangle4 = rectangle(corner=(-lhori/2, -lshift/2, hs), x_size=-3.86mm, y_size=w1)
  Rectangle4.move(7.16mm, 0mm, 0mm)
  Rectangle4.move(1.507mm, 0mm, 0mm)
  Rectangle3.unite(Rectangle1, Rectangle4)
  Rectangle3.move(137.0765mm, 29.509mm, 0.079mm)
  Rectangle3.move(-3.86mm, -7.1054274e-15mm, -0.079mm)
  Rectangle435 = rectangle(corner=(126.953mm, -92.612mm, hs), x_size=3.86mm, y_size=1.602mm)
  Rectangle436 = rectangle(corner=(l2/2, l1/2, hs), x_size=lside, y_size=w1)
  Rectangle437 = rectangle(corner=(-l2/2, -(l1+2*w2)/2, hs), x_size=l2, y_size=(l1+2*w2))
  Rectangle438 = rectangle(corner=(-(l2-2*w1)/2, -l1/2, hs), x_size=l2-2*w1, y_size=l1)
  Rectangle437.subtract(Rectangle438)
  Rectangle439 = rectangle(corner=(-l2/2, -l1/2, hs), x_size=-lside, y_size=-w1)
  Rectangle436.unite(Rectangle437, Rectangle439)
  Rectangle440 = rectangle(corner=(l2/2, -l1/2, hs), x_size=lside, y_size=-w1)
  Rectangle442 = rectangle(corner=(l2/2, l1/2, hs), x_size=lside, y_size=w1)
  Rectangle443 = rectangle(corner=(-l2/2, -(l1+2*w2)/2, hs), x_size=l2, y_size=(l1+2*w2))
  Rectangle444 = rectangle(corner=(-(l2-2*w1)/2, -l1/2, hs), x_size=l2-2*w1, y_size=l1)
  Rectangle443.subtract(Rectangle444)
  Rectangle445 = rectangle(corner=(-l2/2, -l1/2, hs), x_size=-lside, y_size=-w1)
  Rectangle442.unite(Rectangle443, Rectangle445)
  Rectangle442.move(19.136mm, 0mm, 0mm)
  Rectangle441 = rectangle(corner=(l2/2, l1/2, hs), x_size=lside, y_size=w1)
  Rectangle441.move(5.93mm, 0mm, 0mm)
  Rectangle436.unite(Rectangle440, Rectangle442, Rectangle441)
  Rectangle436.move(19.136mm, 11.807mm, 0mm)
  Rectangle436.move(74.772mm, 8.8817842e-16mm, 0mm)
  Rectangle436.move(60.001mm, 3.495mm, -0.635mm)
  Rectangle436.rotate(axis=Y, angle=180deg)
  Rectangle436.move(246.954mm, -49.002mm, 0mm)
  Rectangle436.move(79.48mm, 45.507mm, 0.635mm)
  Rectangle436.move(-30mm, -60mm, 0mm)
  Rectangle436.move(-104.253mm, 23.992mm, 2.2870594e-14mm)
  Rectangle436.move(121.726mm, -45.105mm, 0mm)
  Rectangle436.move(12.527mm, 90.115mm, 1.6986412e-14mm)
  Rectangle446 = rectangle(corner=(l2/2, l1/2, hs), x_size=lside, y_size=w1)
  Rectangle447 = rectangle(corner=(-l2/2, -(l1+2*w2)/2, hs), x_size=l2, y_size=(l1+2*w2))
  Rectangle448 = rectangle(corner=(-(l2-2*w1)/2, -l1/2, hs), x_size=l2-2*w1, y_size=l1)
  Rectangle447.subtract(Rectangle448)
  Rectangle449 = rectangle(corner=(-l2/2, -l1/2, hs), x_size=-lside, y_size=-w1)
  Rectangle446.unite(Rectangle447, Rectangle449)
  Rectangle450 = rectangle(corner=(l2/2, -l1/2, hs), x_size=lside, y_size=-w1)
  Rectangle452 = rectangle(corner=(l2/2, l1/2, hs), x_size=lside, y_size=w1)
  Rectangle453 = rectangle(corner=(-l2/2, -(l1+2*w2)/2, hs), x_size=l2, y_size=(l1+2*w2))
  Rectangle454 = rectangle(corner=(-(l2-2*w1)/2, -l1/2, hs), x_size=l2-2*w1, y_size=l1)
  Rectangle453.subtract(Rectangle454)
  Rectangle455 = rectangle(corner=(-l2/2, -l1/2, hs), x_size=-lside, y_size=-w1)
  Rectangle452.unite(Rectangle453, Rectangle455)
  Rectangle452.move(19.136mm, 0mm, 0mm)
  Rectangle451 = rectangle(corner=(l2/2, l1/2, hs), x_size=lside, y_size=w1)
  Rectangle451.move(5.93mm, 0mm, 0mm)
  Rectangle446.unite(Rectangle450, Rectangle452, Rectangle451)
  Rectangle446.move(19.136mm, 11.807mm, 0mm)
  Rectangle446.move(74.772mm, 8.8817842e-16mm, 0mm)
  Rectangle446.move(60.001mm, 3.495mm, -0.635mm)
  Rectangle446.rotate(axis=Y, angle=180deg)
  Rectangle446.move(246.954mm, -49.002mm, 0mm)
  Rectangle446.move(79.48mm, 45.507mm, 0.635mm)
  Rectangle446.move(-30mm, -60mm, 0mm)
  Rectangle446.move(-104.253mm, 23.992mm, 2.2870594e-14mm)
  Rectangle446.move(121.726mm, -45.105mm, 0mm)
  Rectangle446.move(12.527mm, 90.115mm, 1.6986412e-14mm)
  Rectangle446.move(59.481mm, 0mm, -5.6843419e-14mm)
  Rectangle456 = rectangle(corner=(-lhori/2, -lshift/2, hs), x_size=-3.86mm, y_size=w1)
  Rectangle457 = rectangle(corner=(-lhori/2, -lshift/2, hs), x_size=lhori, y_size=lshift)
  Rectangle458 = rectangle(corner=(-lhori/2+w1, -lshift/2, hs), x_size=lhori-2*w1, y_size=lshift-w1)
  Rectangle457.subtract(Rectangle458)
  Rectangle459 = rectangle(corner=(-lhori/2, -lshift/2, hs), x_size=-3.86mm, y_size=w1)
  Rectangle459.move(7.16mm, 0mm, 0mm)
  Rectangle459.move(1.507mm, 0mm, 0mm)
  Rectangle456.unite(Rectangle457, Rectangle459)
  Rectangle456.move(137.0765mm, 29.509mm, 0.079mm)
  Rectangle456.move(-3.86mm, -7.1054274e-15mm, -0.079mm)
  Rectangle456.move(59.481mm, 2.1316282e-14mm, -5.6732397e-14mm)
  Rectangle460 = rectangle(corner=(186.434mm, 8.107mm, hs), x_size=-w1, y_size=9.002mm)
  Rectangle460.move(20.168mm, -27.109mm, -0.635mm)
  Rectangle460.move(-79.649mm, 36.111mm, 0.635mm)
  Rectangle460.move(59.481mm, -1.0658141e-14mm, 5.7731597e-15mm)
  Rectangle461 = rectangle(corner=(186.434mm, 8.107mm, 0.635mm), x_size=-w1, y_size=9.002mm)
  Rectangle461.move(20.168mm, -27.109mm, -0.635mm)
  Rectangle461.move(-79.649mm, 36.111mm, 0.635mm)
  Rectangle461.move(46.954mm, -19.606mm, 0mm)
  Rectangle461.move(72.008mm, 1.602mm, -3.4083847e-14mm)
  Rectangle461.move(27.818mm, 18.004mm, -3.4083847e-14mm)
  Rectangle462 = rectangle(corner=(-lsubs/2, -w1/2, hs), x_size=8.783mm, y_size=w1)
  Rectangle463 = rectangle(corner=(-lsubs/2+8.783mm, 0mm, hs), x_size=0.997mm, y_size=-4.452mm)
  Rectangle464 = rectangle(corner=(-lsubs/2+8.783mm, 0mm, hs), x_size=0.997mm, y_size=4.452mm)
  Rectangle6 = rectangle(corner=(-0.5965mm, -4.452mm, hs), x_size=3.435mm, y_size=0.997mm)
  Rectangle6.move(-0.605mm, 0mm, 0mm)
  Rectangle6.move(-4.4408921e-16mm, 7.907mm, 0mm)
  Rectangle5 = rectangle(corner=(-0.5965mm, -4.452mm, hs), x_size=3.435mm, y_size=0.997mm)
  Rectangle5.move(-0.605mm, 0mm, 0mm)
  Rectangle465 = rectangle(corner=(-lsubs/2+8.783mm+0.997mm+3.435mm, -4.452mm+0.997mm/2-wend/2, hs), x_size=8.728mm, y_size=wend)
  Rectangle7 = rectangle(corner=(-lsubs/2+8.783mm+0.997mm+3.435mm, 4.452mm-0.997mm/2-wend/2, hs), x_size=8.728mm, y_size=wend)
  Rectangle462.unite(Rectangle463, Rectangle464, Rectangle6, Rectangle5, Rectangle465, Rectangle7)
  Rectangle462.move(284.7145mm, 25.31mm, -6.8167694e-14mm)
  Rectangle462_1 = Rectangle462.duplicate_along_line(step=(-5.6843419e-14mm, -18.004mm, 3.4083847e-14mm), total=2)
  Rectangle462_1_1 = Rectangle462_1.duplicate_along_line(step=(0mm, -36.008mm, 3.4083847e-14mm), total=2)
  Rectangle462_1_2 = Rectangle462_1.duplicate_along_line(step=(1.602mm, -19.606mm, 3.4083847e-14mm), total=2)
  Rectangle462_1_3 = Rectangle462_1.duplicate_along_line(step=(0mm, -54.012mm, 3.4083847e-14mm), total=2)
  Rectangle189_1_1 = Rectangle189_1.duplicate_along_line(step=(5.6843419e-14mm, -70.509mm, -2.8532732e-14mm), total=2)
  [Rectangle189_1, Rectangle462_1_2].move(-1.602mm, 1.602mm, 0mm)
  Rectangle462_1_3_1 = Rectangle462_1_3.duplicate_along_line(step=(5.6843419e-14mm, -27.101mm, -2.8532732e-14mm), total=2)
  Rectangle462_1_3_2 = Rectangle462_1_3.duplicate_along_line(step=(0mm, -12.493mm, 0mm), total=2)
  Rectangle462_1_3_1_1 = Rectangle462_1_3_1.duplicate_along_line(step=(1.602mm, -16.402mm, 0mm), total=2)
  [Rectangle189_1_1, Rectangle462_1_3_1_1].move(-1.602mm, -1.602mm, 0mm)
  Rectangle466 = rectangle(corner=(273.733mm, -56.509mm, hs), x_size=-w1, y_size=-3.491mm)
  Rectangle8.unite(Rectangle20, Rectangle26, Rectangle32, Rectangle42, Rectangle43, Rectangle59, Rectangle60, Rectangle72, Rectangle107, Rectangle122, Rectangle134, Rectangle147, Rectangle157, Rectangle169, Rectangle170, Rectangle176, Rectangle177, Rectangle178, Rectangle188, Rectangle189, Rectangle190, Rectangle196, Rectangle208, Rectangle209, Rectangle210, Rectangle223, Rectangle231, Rectangle233, Rectangle234, Rectangle240, Rectangle241, Rectangle251, Rectangle257, Rectangle269, Rectangle275, Rectangle281, Rectangle291, Rectangle292, Rectangle304, Rectangle314, Rectangle315, Rectangle316, Rectangle326, Rectangle338, Rectangle339, Rectangle340, Rectangle346, Rectangle347, Rectangle355, Rectangle356, Rectangle359, Rectangle365, Rectangle409, Rectangle419, Rectangle421, Rectangle424, Rectangle434, Rectangle3, Rectangle435, Rectangle436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)
  Rectangle357 = rectangle(corner=(-22.591mm, 8.107mm, hs), y_size=-w1, z_size=-hsubst)
  Rectangle357_1 = Rectangle357.duplicate_along_line(step=(0mm, -9.002mm, 3.3306691e-16mm), total=2)
  Rectangle357_1_1 = Rectangle357_1.duplicate_along_line(step=(0mm, -9.002mm, 0mm), total=2)
  Rectangle357_1_1_1 = Rectangle357_1_1.duplicate_along_line(step=(0mm, -9.002mm, 0mm), total=2)
  Rectangle357_1_1_1_1 = Rectangle357_1_1_1.duplicate_along_line(step=(1.0658141e-14mm, -27.101mm, 0mm), total=2)
  Rectangle357_1_1_1_1_1, Rectangle357_1_1_1_1_2, Rectangle357_1_1_1_1_3 = Rectangle357_1_1_1_1.duplicate_along_line(step=(0mm, -9.002mm, 0mm), total=4)
  Box1 [Rogers RT/duroid 5880 (tm)] = box(corner=(273.733mm+21.943mm, 37.109mm, hs), size=(-296.324mm-21.943mm, -141.717mm, -hsubst))
  Rectangle467 = rectangle(corner=(295.676mm, 30.243mm, hs), y_size=-wend, z_size=-hs)
  Rectangle467_1 = Rectangle467.duplicate_along_line(step=(0mm, -7.907mm, 0mm), total=2)
  Rectangle467_1_1 = Rectangle467_1.duplicate_along_line(step=(0mm, -10.097mm, -3.4083847e-14mm), total=2)
  Rectangle467_1_1_1 = Rectangle467_1_1.duplicate_along_line(step=(0mm, -7.907mm, 0mm), total=2)
  Rectangle467_1_1_1_1 = Rectangle467_1_1_1.duplicate_along_line(step=(0mm, -10.097mm, 3.4083847e-14mm), total=2)
  Rectangle467_1_1_1_1_1 = Rectangle467_1_1_1_1.duplicate_along_line(step=(0mm, -7.907mm, 0mm), total=2)
  Rectangle467_1_1_1_1_1_1 = Rectangle467_1_1_1_1_1.duplicate_along_line(step=(0mm, -10.097mm, 0mm), total=2)
  Rectangle467_1_1_1_1_1_1_1 = Rectangle467_1_1_1_1_1_1.duplicate_along_line(step=(0mm, -7.907mm, 0mm), total=2)
  Rectangle467_1_1_1_1_1_1_1_1 = Rectangle467_1_1_1_1_1_1_1.duplicate_along_line(step=(0mm, -10.097mm, 0mm), total=2)
  Rectangle467_1_1_1_1_1_1_1_1_1 = Rectangle467_1_1_1_1_1_1_1_1.duplicate_along_line(step=(0mm, -7.907mm, 0mm), total=2)
  Rectangle467_1_1_1_1_1_1_1_1_1_1 = Rectangle467_1_1_1_1_1_1_1_1_1.duplicate_along_line(step=(0mm, -4.586mm, 0mm), total=2)
  Rectangle467_1_1_1_1_1_1_1_1_1_1_1 = Rectangle467_1_1_1_1_1_1_1_1_1_1.duplicate_along_line(step=(0mm, -7.907mm, 0mm), total=2)
  Rectangle467_1_1_1_1_1_1_1_1_1_1_1_1 = Rectangle467_1_1_1_1_1_1_1_1_1_1_1.duplicate_along_line(step=(5.6843419e-14mm, -6.701mm, -2.8532732e-14mm), total=2)
  Rectangle467_1_1_1_1_1_1_1_1_1_1_1_1_1 = Rectangle467_1_1_1_1_1_1_1_1_1_1_1_1.duplicate_along_line(step=(0mm, -7.907mm, 0mm), total=2)
  Rectangle467_1_1_1_1_1_1_1_1_1_1_1_1_1_1 = Rectangle467_1_1_1_1_1_1_1_1_1_1_1_1_1.duplicate_along_line(step=(0mm, -10.097mm, 0mm), total=2)
  Rectangle467_1_1_1_1_1_1_1_1_1_1_1_1_1_1_1 = Rectangle467_1_1_1_1_1_1_1_1_1_1_1_1_1_1.duplicate_along_line(step=(0mm, -7.907mm, 0mm), total=2)
  Rectangle468 = rectangle(corner=(-22.591mm, -104.608mm, 0mm), x_size=318.267mm, y_size=141.717mm)
  [Rectangle8, Rectangle357, Rectangle357_1, Rectangle357_1_1, Rectangle357_1_1_1, Rectangle357_1_1_1_1, Rectangle357_1_1_1_1_1, Rectangle357_1_1_1_1_2, Rectangle357_1_1_1_1_3, Box1, Rectangle467, Rectangle467_1, Rectangle467_1_1, Rectangle467_1_1_1, Rectangle467_1_1_1_1, Rectangle467_1_1_1_1_1, Rectangle467_1_1_1_1_1_1, Rectangle467_1_1_1_1_1_1_1, Rectangle467_1_1_1_1_1_1_1_1, Rectangle467_1_1_1_1_1_1_1_1_1, Rectangle467_1_1_1_1_1_1_1_1_1_1, Rectangle467_1_1_1_1_1_1_1_1_1_1_1, Rectangle467_1_1_1_1_1_1_1_1_1_1_1_1, Rectangle467_1_1_1_1_1_1_1_1_1_1_1_1_1, Rectangle467_1_1_1_1_1_1_1_1_1_1_1_1_1_1, Rectangle467_1_1_1_1_1_1_1_1_1_1_1_1_1_1_1, Rectangle468].rotate(axis=Y, angle=90deg)
  [Rectangle8, Rectangle357, Rectangle357_1, Rectangle357_1_1, Rectangle357_1_1_1, Rectangle357_1_1_1_1, Rectangle357_1_1_1_1_1, Rectangle357_1_1_1_1_2, Rectangle357_1_1_1_1_3, Box1, Rectangle467, Rectangle467_1, Rectangle467_1_1, Rectangle467_1_1_1, Rectangle467_1_1_1_1, Rectangle467_1_1_1_1_1, Rectangle467_1_1_1_1_1_1, Rectangle467_1_1_1_1_1_1_1, Rectangle467_1_1_1_1_1_1_1_1, Rectangle467_1_1_1_1_1_1_1_1_1, Rectangle467_1_1_1_1_1_1_1_1_1_1, Rectangle467_1_1_1_1_1_1_1_1_1_1_1, Rectangle467_1_1_1_1_1_1_1_1_1_1_1_1, Rectangle467_1_1_1_1_1_1_1_1_1_1_1_1_1, Rectangle467_1_1_1_1_1_1_1_1_1_1_1_1_1_1, Rectangle467_1_1_1_1_1_1_1_1_1_1_1_1_1_1_1, Rectangle468].move(-0.635mm, 42.891mm, 77.409mm)
  [Rectangle8, Rectangle357, Rectangle357_1, Rectangle357_1_1, Rectangle357_1_1_1, Rectangle357_1_1_1_1, Rectangle357_1_1_1_1_1, Rectangle357_1_1_1_1_2, Rectangle357_1_1_1_1_3, Box1, Rectangle467, Rectangle467_1, Rectangle467_1_1, Rectangle467_1_1_1, Rectangle467_1_1_1_1, Rectangle467_1_1_1_1_1, Rectangle467_1_1_1_1_1_1, Rectangle467_1_1_1_1_1_1_1, Rectangle467_1_1_1_1_1_1_1_1, Rectangle467_1_1_1_1_1_1_1_1_1, Rectangle467_1_1_1_1_1_1_1_1_1_1, Rectangle467_1_1_1_1_1_1_1_1_1_1_1, Rectangle467_1_1_1_1_1_1_1_1_1_1_1_1, Rectangle467_1_1_1_1_1_1_1_1_1_1_1_1_1, Rectangle467_1_1_1_1_1_1_1_1_1_1_1_1_1_1, Rectangle467_1_1_1_1_1_1_1_1_1_1_1_1_1_1_1, Rectangle468].rotate(axis=Y, angle=180deg)
  [Rectangle8, Rectangle357, Rectangle357_1, Rectangle357_1_1, Rectangle357_1_1_1, Rectangle357_1_1_1_1, Rectangle357_1_1_1_1_1, Rectangle357_1_1_1_1_2, Rectangle357_1_1_1_1_3, Box1, Rectangle467, Rectangle467_1, Rectangle467_1_1, Rectangle467_1_1_1, Rectangle467_1_1_1_1, Rectangle467_1_1_1_1_1, Rectangle467_1_1_1_1_1_1, Rectangle467_1_1_1_1_1_1_1, Rectangle467_1_1_1_1_1_1_1_1, Rectangle467_1_1_1_1_1_1_1_1_1, Rectangle467_1_1_1_1_1_1_1_1_1_1, Rectangle467_1_1_1_1_1_1_1_1_1_1_1, Rectangle467_1_1_1_1_1_1_1_1_1_1_1_1, Rectangle467_1_1_1_1_1_1_1_1_1_1_1_1_1, Rectangle467_1_1_1_1_1_1_1_1_1_1_1_1_1_1, Rectangle467_1_1_1_1_1_1_1_1_1_1_1_1_1_1_1, Rectangle468].move(-0.635mm, 1.717mm, -80mm)
  patch1 = rectangle(corner=((-12/2) mm, (-19.3/2) mm, h), x_size=12mm, y_size=19.3mm)
  Rectangle474 = rectangle(corner=(-5.1mm, -3.85mm, h), x_size=0.7mm, y_size=7.7mm)
  Rectangle475 = rectangle(corner=(-4.4mm, -3.85mm, h), x_size=10.4mm, y_size=0.5mm)
  Rectangle476 = rectangle(corner=(-4.4mm, -3.85mm, h), x_size=10.4mm, y_size=0.5mm)
  Rectangle476.move(8.8817842e-16mm, 7.2mm, -4.4408921e-16mm)
  Rectangle474.unite(Rectangle475, Rectangle476)
  patch1.subtract(Rectangle474)
  Rectangle477 = rectangle(corner=(-7.9mm, -0.4mm, h), x_size=1.9mm, y_size=0.8mm)
  patch1.unite(Rectangle477)
  patch1.move(0mm, -30mm, 0mm)
  patch2 = rectangle(corner=((-12/2) mm, (-19.3/2) mm, h), x_size=12mm, y_size=19.3mm)
  Rectangle482 = rectangle(corner=(-5.1mm, -3.85mm, h), x_size=0.7mm, y_size=7.7mm)
  Rectangle483 = rectangle(corner=(-4.4mm, -3.85mm, h), x_size=10.4mm, y_size=0.5mm)
  Rectangle484 = rectangle(corner=(-4.4mm, -3.85mm, h), x_size=10.4mm, y_size=0.5mm)
  Rectangle484.move(8.8817842e-16mm, 7.2mm, -4.4408921e-16mm)
  Rectangle482.unite(Rectangle483, Rectangle484)
  patch2.subtract(Rectangle482)
  Rectangle485 = rectangle(corner=(-7.9mm, -0.4mm, h), x_size=1.9mm, y_size=0.8mm)
  patch2.unite(Rectangle485)
  patch2.move(-30mm, 0mm, 0mm)
  patch3 = rectangle(corner=((-12/2) mm, (-19.3/2) mm, h), x_size=12mm, y_size=19.3mm)
  Rectangle486 = rectangle(corner=(-5.1mm, -3.85mm, h), x_size=0.7mm, y_size=7.7mm)
  Rectangle487 = rectangle(corner=(-4.4mm, -3.85mm, h), x_size=10.4mm, y_size=0.5mm)
  Rectangle488 = rectangle(corner=(-4.4mm, -3.85mm, h), x_size=10.4mm, y_size=0.5mm)
  Rectangle488.move(8.8817842e-16mm, 7.2mm, -4.4408921e-16mm)
  Rectangle486.unite(Rectangle487, Rectangle488)
  patch3.subtract(Rectangle486)
  Rectangle489 = rectangle(corner=(-7.9mm, -0.4mm, h), x_size=1.9mm, y_size=0.8mm)
  patch3.unite(Rectangle489)
  patch3.move(-30mm, -30mm, 0mm)
  Rectangle473 = rectangle(corner=(-7.9mm, -0.4mm, h), x_size=0.8mm, y_size=-29.2mm)
  Rectangle478 = rectangle(corner=(-7.9mm, -13.75mm, h), x_size=-5mm, y_size=-2.5mm)
  Rectangle479 = rectangle(corner=(-12.9mm, -14.375mm, h), x_size=-19.2mm, y_size=-1.25mm)
  Rectangle481 = rectangle(corner=(-37.1mm, -0.4mm, h), x_size=-0.8mm, y_size=-29.2mm)
  Rectangle480 = rectangle(corner=(-32.1mm, -13.75mm, h), x_size=-5mm, y_size=-2.5mm)
  Rectangle473.unite(Rectangle478, Rectangle479, Rectangle481, Rectangle480)
  patch = rectangle(corner=((-12/2) mm, (-19.3/2) mm, h), x_size=12mm, y_size=19.3mm)
  Rectangle469 = rectangle(corner=(-5.1mm, -3.85mm, h), x_size=0.7mm, y_size=7.7mm)
  Rectangle470 = rectangle(corner=(-4.4mm, -3.85mm, h), x_size=10.4mm, y_size=0.5mm)
  Rectangle471 = rectangle(corner=(-4.4mm, -3.85mm, h), x_size=10.4mm, y_size=0.5mm)
  Rectangle471.move(8.8817842e-16mm, 7.2mm, -4.4408921e-16mm)
  Rectangle469.unite(Rectangle470, Rectangle471)
  patch.subtract(Rectangle469)
  Rectangle472 = rectangle(corner=(-7.9mm, -0.4mm, h), x_size=1.9mm, y_size=0.8mm)
  patch.unite(Rectangle472)
  patch1.unite(patch2, patch3, Rectangle473, patch)
  substrate [Arlon AD270 (tm)] = box(corner=(-45mm, -45mm, h), size=(60mm, 60mm, -h))
  feed_line [copper] = cylinder(axis=Z, base_centre=(-22.5mm, -15mm, -3mm), radius=0.63mm, height=3mm+h)
  feed_line_1 = feed_line.copy()
  substrate.subtract(feed_line_1)
  ground = rectangle(corner=(-45mm, -45mm, 0mm), x_size=60mm, y_size=60mm)
  feed_dielec [Teflon (tm)] = cylinder(axis=Z, base_centre=(-22.5mm, -15mm, 0mm), radius=2mm, height=-3mm)
  Cylinder1_1 = feed_dielec.copy()
  ground.subtract(Cylinder1_1)
  feed_cover [copper] = object_from(feed_dielec.face(at (-24.5, -15, -1.5)))
  feed_cover.thicken(Cuthick)
  Cylinder1_ObjectFromFace1_1 = feed_cover.copy()
  ground.subtract(Cylinder1_ObjectFromFace1_1)
  port_cap [pec] = object_from(feed_dielec.face(2 of 3))
  feed_line_2 = feed_line.copy()
  feed_dielec.subtract(feed_line_2)
  port_cap.thicken(Cuthick)
  [patch1, substrate, ground, feed_dielec, feed_line, feed_cover, port_cap].move(0mm, 345mm, 0mm)
  [patch1, substrate, ground, feed_dielec, feed_line, feed_cover, port_cap].rotate(axis=X, angle=90deg)
  [patch1, substrate, ground, feed_dielec, feed_line, feed_cover, port_cap].move(0mm, -297.5mm, 0mm)
  [patch1, substrate, ground, feed_dielec, feed_line, feed_cover, port_cap].move(23.13mm, -0.5mm, 0mm)
  [patch1, substrate, ground, feed_dielec, feed_line, feed_cover, port_cap].move(0mm, 0mm, -250mm)
  [patch1, substrate, ground, feed_dielec, feed_line, feed_cover, port_cap].rotate(axis=Y, angle=-90deg)
  [patch1, substrate, ground, feed_dielec, feed_line, feed_cover, port_cap].move(80mm, 0mm, 0mm)
  patch1_1..patch1_15 = patch1.duplicate_around_axis(axis=Z, angle=22.5deg, total=16)
  substrate_1..substrate_15 [Arlon AD270 (tm)] = substrate.duplicate_around_axis(axis=Z, angle=22.5deg, total=16)
  ground_1..ground_15 = ground.duplicate_around_axis(axis=Z, angle=22.5deg, total=16)
  feed_dielec_1..feed_dielec_15 [Teflon (tm)] = feed_dielec.duplicate_around_axis(axis=Z, angle=22.5deg, total=16)
  feed_line_3..feed_line_17 [copper] = feed_line.duplicate_around_axis(axis=Z, angle=22.5deg, total=16)
  feed_cover_1..feed_cover_15 [copper] = feed_cover.duplicate_around_axis(axis=Z, angle=22.5deg, total=16)
  port_cap_1..port_cap_15 [pec] = port_cap.duplicate_around_axis(axis=Z, angle=22.5deg, total=16)
  Polyline1 = polyline((-0.635mm, -51.1565mm, 138.267mm) (112.89161mm, -272.54446mm, 0mm))
  Polyline2 = polyline((-0.635mm, -43.2495mm, 138.267mm) (208.5965mm, -208.5965mm, 0mm))
  Polyline3 = polyline((-0.635mm, -33.1525mm, 138.267mm) (272.54446mm, -112.89161mm, 0mm))
  Polyline4 = polyline((-0.3175mm, -25.2455mm, 138.267mm) (294.95mm, 0mm, 0.63mm))
  Polyline5 = polyline((-0.3175mm, -18.5445mm, 138.267mm) (272.49827mm, 112.87248mm, 0.63mm))
  Polyline6 = polyline(xyz in mm: (-0.635, 1.8555, 138.267) (-0.635, 1.8555, 150) (208.56115, 208.56115, 0.63), Spline from point 0 over 3)
  Polyline7 = polyline(xyz in mm: (-0.635, 11.9525, 138.267) (-0.635, 11.9525, 146) (112.87248, 272.49827, 0.63), Spline from point 0 over 3)
  Polyline8 = polyline(xyz in mm: (-0.635, 19.8595, 138.267) (-0.635, 19.8595, 150) (1, 19.8595, 150) (0, 294.95, 0.63), Spline from point 0 over 4)
  Polyline9 = polyline((-0.635mm, 29.9565mm, 138.267mm) (-112.87248mm, 272.49827mm, 0.63mm))
  Polyline10 = polyline((-0.635mm, 37.8635mm, 138.267mm) (-208.5965mm, 208.5965mm, 0mm))
  Polyline11 = polyline((-0.635mm, 47.9605mm, 138.267mm) (-272.49827mm, 112.87248mm, 0.63mm))
  Polyline12 = polyline((-0.635mm, 55.8675mm, 138.267mm) (-294.95mm, 0mm, 0.63mm))
  Polyline13 = polyline(xyz in mm: (0, 65.9645, 138.267) (0, 65.9645, 158) (-272.49827, -112.87248, 0.63), Spline from point 0 over 3)
  Polyline15 = polyline((-0.635mm, -10.6375mm, 138.267mm) (-208.56115mm, -208.56115mm, 0.63mm))
  Polyline16 = polyline((-0.635mm, -6.0515mm, 138.267mm) (-112.87248mm, -272.49827mm, 0.63mm))
  Polyline17 = polyline(xyz in mm: (-0.635, 73.8715, 138.267) (-0.635, 73.8715, 240) (0, -294.95, 0.63), Spline from point 0 over 3)
  Polyline1_1 = Polyline1.copy()
  Polyline1_1.delete()
  Polyline10_1 = Polyline10.copy()
  Polyline10_1.delete()
  Polyline11_1 = Polyline11.copy()
  Polyline11_1.delete()
  Polyline12_1 = Polyline12.copy()
  Polyline12_1.delete()
  Polyline13_1 = Polyline13.copy()
  Polyline13_1.delete()
  Polyline15_1 = Polyline15.copy()
  Polyline15_1.delete()
  Polyline16_1 = Polyline16.copy()
  Polyline16_1.delete()
  Polyline17_1 = Polyline17.copy()
  Polyline17_1.delete()
  Polyline2_1 = Polyline2.copy()
  Polyline2_1.delete()
  Polyline3_1 = Polyline3.copy()
  Polyline3_1.delete()
  Polyline4_1 = Polyline4.copy()
  Polyline4_1.delete()
  Polyline5_1 = Polyline5.copy()
  Polyline5_1.delete()
  Polyline6_1 = Polyline6.copy()
  Polyline6_1.delete()
  Polyline7_1 = Polyline7.copy()
  Polyline7_1.delete()
  Polyline8_1 = Polyline8.copy()
  Polyline8_1.delete()
  Polyline9_1 = Polyline9.copy()
  Polyline9_1.delete()
  Cylinder1 [pec, non-model] = imported_body()
  Box2 [air] = box(corner=(750mm, 500mm, 375mm), size=(-1100mm, -1200mm, -750mm))
boundaries and excitations:
  PerfE4: Perfect E Objects=Rectangle8
  PerfE5: Perfect E Objects=[Rectangle468, Rectangle467_1_1_1_1_1_1_1_1_1_1_1_1_1_1_1, Rectangle467_1_1_1_1_1_1_1_1_1_1_1_1_1_1, Rectangle467_1_1_1_1_1_1_1_1_1_1_1_1_1, Rectangle467_1_1_1_1_1_1_1_1_1_1_1_1, Rectangle467_1_1_1_1_1_1_1_1_1_1_1, Rectangle467_1_1_1_1_1_1_1_1_1_1, Rectangle467_1_1_1_1_1_1_1_1_1, Rectangle467_1_1_1_1_1_1_1_1, Rectangle467_1_1_1_1_1_1_1, Rectangle467_1_1_1_1_1_1, Rectangle467_1_1_1_1_1, Rectangle467_1_1_1_1, Rectangle467_1_1_1, Rectangle467_1_1, Rectangle467_1, Rectangle467]
  PerfE1: Perfect E Objects=ground
  PerfE2: Perfect E Objects=patch1
  PerfE6: Perfect E Objects=ground_1
  PerfE7: Perfect E Objects=patch1_1
  PerfE8: Perfect E Objects=ground_2
  PerfE9: Perfect E Objects=patch1_2
  PerfE10: Perfect E Objects=ground_3
  PerfE11: Perfect E Objects=patch1_3
  PerfE12: Perfect E Objects=ground_4
  PerfE13: Perfect E Objects=patch1_4
  PerfE14: Perfect E Objects=ground_5
  PerfE15: Perfect E Objects=patch1_5
  PerfE16: Perfect E Objects=ground_6
  PerfE17: Perfect E Objects=patch1_6
  PerfE18: Perfect E Objects=ground_7
  PerfE19: Perfect E Objects=patch1_7
  PerfE20: Perfect E Objects=ground_8
  PerfE21: Perfect E Objects=patch1_8
  PerfE22: Perfect E Objects=ground_9
  PerfE23: Perfect E Objects=patch1_9
  PerfE24: Perfect E Objects=ground_10
  PerfE25: Perfect E Objects=patch1_10
  PerfE26: Perfect E Objects=ground_11
  PerfE27: Perfect E Objects=patch1_11
  PerfE28: Perfect E Objects=ground_12
  PerfE29: Perfect E Objects=patch1_12
  PerfE30: Perfect E Objects=ground_13
  PerfE31: Perfect E Objects=patch1_13
  PerfE32: Perfect E Objects=ground_14
  PerfE33: Perfect E Objects=patch1_14
  PerfE34: Perfect E Objects=ground_15
  PerfE35: Perfect E Objects=patch1_15
  PerfE36: Perfect E Objects=[Polyline1..Polyline13, Polyline15, Polyline16, Polyline17]
  Rad1: Radiation Objects=Box2
  1: Lumped Port Objects=Rectangle357 LumpedPortType=Modal Modes{Mode1{IntLine{(0, 51.914, -180) -> (-0.635, 51.914, -180)} CharImp=Zpi RenormImp=50ohm}} Impedance=50ohm
  2: Lumped Port Objects=Rectangle357_1 LumpedPortType=Modal Modes{Mode1{IntLine{(0, 42.912, -180) -> (-0.635, 42.912, -180)} CharImp=Zpi RenormImp=50ohm}} Impedance=50ohm
  3: Lumped Port Objects=Rectangle357_1_1 LumpedPortType=Modal Modes{Mode1{IntLine{(0, 33.91, -180) -> (-0.635, 33.91, -180)} CharImp=Zpi RenormImp=50ohm}} Impedance=50ohm
  4: Lumped Port Objects=Rectangle357_1_1_1 LumpedPortType=Modal Modes{Mode1{IntLine{(0, 24.908, -180) -> (-0.635, 24.908, -180)} CharImp=Zpi RenormImp=50ohm}} Impedance=50ohm
  5: Lumped Port Objects=Rectangle357_1_1_1_1 LumpedPortType=Modal Modes{Mode1{IntLine{(0, -2.193, -180) -> (-0.635, -2.193, -180)} CharImp=Zpi RenormImp=50ohm}} Impedance=50ohm
  6: Lumped Port Objects=Rectangle357_1_1_1_1_1 LumpedPortType=Modal Modes{Mode1{IntLine{(0, -11.195, -180) -> (-0.635, -11.195, -180)} CharImp=Zpi RenormImp=50ohm}} Impedance=50ohm
  7: Lumped Port Objects=Rectangle357_1_1_1_1_2 LumpedPortType=Modal Modes{Mode1{IntLine{(0, -20.197, -180) -> (-0.635, -20.197, -180)} CharImp=Zpi RenormImp=50ohm}} Impedance=50ohm
  8: Lumped Port Objects=Rectangle357_1_1_1_1_3 LumpedPortType=Modal Modes{Mode1{IntLine{(0, -29.199, -180) -> (-0.635, -29.199, -180)} CharImp=Zpi RenormImp=50ohm}} Impedance=50ohm
setups:
  Setup1: HfssDriven Frequency=6.24GHz MaxDeltaS=0.02 MaximumPasses=6 MinimumPasses=1 MinimumConvergedPasses=1 PercentRefinement=30 BasisOrder=1 PortAccuracy=2 DrivenSolverType="Direct Solver"
    sweep Sweep: 4GHz to 8GHz, 401 points; Type=Interpolating InterpTolerance=0.5 InterpMaxSolns=250 PassivityErrorTolerance=0.0001
source amplitudes:
  1:1, 2:1, 3:1, 4:1, 5:1, 6:1, 7:1, 8:1: 1V 0deg
