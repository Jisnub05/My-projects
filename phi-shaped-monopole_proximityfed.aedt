# Ansys Electronics Desktop project, version 2025.2
materials:
  vacuum: permittivity=1
  Rogers Ultralam 2000 (tm): permittivity=2.5 dielectric_loss_tangent=0.0019
  Teflon (tm): permittivity=2.1 dielectric_loss_tangent=0.001
  copper: permeability=0.999991 conductivity=58000000
  foam: permittivity=1.06 dielectric_loss_tangent=0.0002
  pec: conductivity=1e+30

design HFSSDesign1 (HFSS, HFSS Modal Network, model units mm)
variables:
  h2 = 0.365mm
  y_cyl = 9mm
  r_in = 0.6mm
  hout = 3mm
  ls = 100mm
  ws = 100mm
  x_cyl = 0
  h1 = 6mm
  r_out = 2mm
  wpad = 5mm
  lpad = 5mm
  lp = 60mm
  w50 = 2.25mm
  lcut = 13mm
  l_tune = 4mm
  wp = 40mm
  wcut = 24mm
  thickCu = 0.017mm
  wrad = 200mm
  lrad = 200mm
  hrad = 100mm
  wgnd = 23.2mm
  gap = 2.8mm
  lcut_gnd = 14mm
  wcut_gnd = 6mm
  x_plate = 2.25mm
  y_plate = 2.25mm
geometry:
  Box1 [foam] = box(corner=(-ls/2, -ws/2, 0mm), size=(ls, ws, h1))
  Cylinder2 [copper] = cylinder(axis=Z, base_centre=(x_cyl, y_cyl, h1), radius=r_in, height=-hout-h1)
  Cylinder2_1 = Cylinder2.copy()
  Cylinder2_2 = Cylinder2.copy()
  Box1.subtract(Cylinder2_2)
  Box2 [Rogers Ultralam 2000 (tm)] = box(corner=(-ls/2, -ws/2, h1), size=(ls, ws, h2))
  Box2.subtract(Cylinder2_1)
  Rectangle1 = rectangle(corner=(-lpad/2, y_cyl-wpad/2, 0mm), x_size=lpad, y_size=wpad)
  Cylinder1 [Teflon (tm)] = cylinder(axis=Z, base_centre=(x_cyl, y_cyl, 0mm), radius=r_out, height=-hout)
  Cylinder1_ObjectFromFace1 [copper] = object_from(Cylinder1.face(side))
  Cylinder1_ObjectFromFace2 [pec] = object_from(Cylinder1.face(-z end))
  Cylinder1_1 = Cylinder1.copy()
  Rectangle1.subtract(Cylinder1_1)
  Rectangle2 = rectangle(corner=(-lp/2, -wp/2, h1+h2), x_size=lp, y_size=wp)
  Rectangle4 = rectangle(corner=(w50/2, wp/2, h1+h2), x_size=lcut, y_size=-wcut)
  Rectangle5 = rectangle(corner=(-w50/2, wp/2, h1+h2), x_size=-lcut, y_size=-wcut)
  Rectangle2.subtract(Rectangle4, Rectangle5)
  Rectangle3 = rectangle(corner=(-w50/2, -wp/2, h1+h2), x_size=w50, y_size=-l_tune)
  Rectangle2.unite(Rectangle3)
  patch [copper] = object_from(Rectangle2.face(at (0, -2, 6.365)))
  Cylinder2_3 = Cylinder2.copy()
  Cylinder1.subtract(Cylinder2_3)
  [Cylinder1_ObjectFromFace1, Cylinder1_ObjectFromFace2].thicken(thickCu)
  Cylinder1_ObjectFromFace2.move_faces(MoveAlongNormalFlag=true OffsetDistance=thickCu FacesToMove=Cylinder1_ObjectFromFace2.face(at (2, 9, -3.0085)))
  patch.thicken(thickCu)
  Box3 [vacuum] = box(corner=(-lrad/2, -wrad/2, -hrad/2), size=(lrad, wrad, hrad))
  Rectangle6 = rectangle(corner=(-ls/2, -ws/2, 0mm), x_size=ls, y_size=wgnd)
  Rectangle7 = rectangle(corner=(-lcut_gnd/2, -ls/2+wgnd, 0mm), x_size=lcut_gnd, y_size=-wcut_gnd)
  Rectangle6.subtract(Rectangle7)
  Rectangle8 = rectangle(corner=(x_cyl-x_plate/2, y_cyl-y_plate/2, h1), x_size=x_plate, y_size=y_plate)
  Rectangle9 = rectangle(corner=(42mm, -50mm, 0mm), x_size=-14mm, y_size=14mm)
  Rectangle10 = rectangle(corner=(-42mm, -50mm, 0mm), x_size=14mm, y_size=14mm)
  Rectangle6.subtract(Rectangle10, Rectangle9)
boundaries and excitations:
  PerfE1: Perfect E Objects=Rectangle1
  PerfE2: Perfect E Objects=Rectangle2
  Rad1: Radiation Objects=Box3
  PerfE3: Perfect E Objects=Rectangle6
  PerfE4: Perfect E Objects=Rectangle8
  1: Wave Port Faces=Cylinder1.face(-z end) WavePortType=Modal NumModes=1 Modes{Mode1{IntLine{(0.6, 9, -3) -> (2, 9, -3)} CharImp=Zpi RenormImp=50ohm}}
setups:
  Setup1: HfssDriven Frequency=5.5GHz MaxDeltaS=0.02 MaximumPasses=15 MinimumPasses=1 MinimumConvergedPasses=1 PercentRefinement=30 BasisOrder=1 PortAccuracy=2 DrivenSolverType="Direct Solver"
    sweep Sweep: 4GHz to 15GHz, 200 points; Type=Fast SaveFields
source amplitudes:
  1:1: 1W 0deg
optimetrics:
  ParametricSetup1: Parametric Sim._Setups=[Setup1]
    sweep h2: LIN 0.165mm 0.495mm 0.1mm
radiation setups:
  Infinite Sphere1: Infinite Sphere Theta=-180deg..180deg step 2deg Phi=-180deg..180deg step 2deg
field plots:
  Vector_Jsurf1: Jsurf over patch.face(all 18) on Setup1 : Sweep at Freq=5.8794GHz Phase=0deg
  Vector_Jsurf2: Jsurf over patch.face(all 18) on Setup1 : Sweep at Freq=8.25628GHz Phase=0deg
  Vector_Jsurf3: Jsurf over Rectangle6.face(at (0, -38.4, 0)) on Setup1 : Sweep at Freq=8.69849GHz Phase=0deg
reports:
  S Parameter Plot1: dB(S(1,1)) vs Freq on Setup1 : Sweep; markers m1 at 6.4321608GHz, m3 at 8.2562814GHz, MY1 at y=-10
  S Parameter Chart1: S(1,1) on Setup1 : Sweep [Freq=all y_cyl=9mm w50=2.25mm l_tune=4mm wcut=24mm]; markers m1 at 5.89GHz, m2 at 8.2562814GHz
  Z Parameter Plot1: im(Z(1,1)) vs Freq on Setup1 : Sweep [y_cyl=9mm l_tune=4mm wcut=24mm]; markers MY1 at y=0
  Gain Plot3: dB(GainPhi), dB(GainTheta) vs Theta on Setup1 : Sweep, Infinite Sphere1 [Phi=0deg Freq=4GHz wgnd=23.2mm,23.2mm]; markers m1 at 90deg, m2 at 0deg
  Z Parameter Plot2: re(Z(1,1)), im(Z(1,1)) vs Freq on Setup1 : Sweep [wgnd=23.2mm]; markers m1 at 6.6532663GHz, MY1 at y=0
  Gain Plot4: dB(GainTotal) vs Phi, Theta on Setup1 : Sweep, Infinite Sphere1 [Freq=8.03518GHz h2=0.365mm wgnd=23.2mm]
  Gain Plot5: dB(GainTotal) vs Freq on Setup1 : Sweep, Infinite Sphere1 [Phi=0deg Theta=0deg h2=0.365mm wgnd=23.2mm]; markers m1 at 6.6532663GHz, m2 at 8.74GHz, MY1 at y=0
  Gain Plot6: dB(GainPhi), dB(GainTheta) vs Theta on Setup1 : Sweep, Infinite Sphere1 [Phi=90deg Freq=4GHz wgnd=23.2mm,23.2mm]
  Gain Plot7: dB(GainTotal) vs Phi, Theta on Setup1 : Sweep, Infinite Sphere1 [Freq=6.43216GHz h2=0.365mm wgnd=23.2mm]
  Gain Plot8: dB(GainLHCP), dB(GainRHCP) vs Freq on Setup1 : Sweep, Infinite Sphere1 [Freq=6.70854GHz Phi=0deg Theta=all h2=0.365mm wgnd=23.2mm]
  Gain Plot9: dB(GainLHCP), dB(GainRHCP), dB(GainTotal) vs Theta on Setup1 : Sweep, Infinite Sphere1 [Phi=0deg Freq=6.70854GHz h2=0.365mm wgnd=23.2mm]
  Gain Plot10: dB(GainTotal) vs Theta, Phi on Setup1 : Sweep, Infinite Sphere1 [Freq=6.70854GHz h2=0.365mm wgnd=23.2mm]
