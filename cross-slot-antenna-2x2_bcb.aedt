# Ansys Electronics Desktop project, version 2024.2
materials:
  vacuum: permittivity=1
  Teflon (tm): permittivity=2.1 dielectric_loss_tangent=0.001
  benzocyclobuten: permittivity=2.6
  copper: permeability=0.999991 conductivity=58000000
  pec: conductivity=1e+30
  air: permittivity=1.0006 permeability=1.0000004

design HFSSDesign1 (HFSS, HFSS Terminal Network, model units mm)
variables:
  h = 50um
  h1 = 1mm
  wgnd = 12mm
  lgnd = 16mm
  rf1 = 0.2mm
  rf = 0.5mm
  Cuthick = 0.0028mm
  lmid = 4.71mm
  wmid = 0.45mm
  wmid1 = 0.259mm
  lmid1 = 0.472mm
  d = 4.85mm
  d_width = 0.14mm
  slotv_L = 0.3mm
  depth = 0.22mm
  slotv_W = 0.1mm
  sloth_L = 0.2mm
  sloth_W = 0.1mm
  s = 0.14mm
  sl = 4.12mm
  wp = 1.06mm
  lp = 0.835mm
  ml = 2.416mm
  mw = 0.14mm
  air = 17mm
geometry:
  ground = rectangle(corner=(-lgnd/2, -wgnd/2, 0mm), x_size=lgnd-3mm, y_size=wgnd)
  feed_dielec [Teflon (tm)] = cylinder(axis=Z, base_centre=(0mm, 0mm, 0mm), radius=rf, height=-h1)
  feed_cover [copper] = object_from(feed_dielec.face(side))
  port_cap [pec] = object_from(feed_dielec.face(-z end))
  feed_line [copper] = cylinder(axis=Z, base_centre=(0mm, 0mm, -h1), radius=rf1, height=h1+h)
  feed_line_2 = feed_line.copy()
  feed_dielec.subtract(feed_line_2)
  feed_dielec_1 = feed_dielec.copy()
  ground.subtract(feed_dielec_1)
  feed_line_3 = feed_line.copy()
  feed_line_4 = feed_line.copy()
  ground.subtract(feed_line_4)
  substrate [benzocyclobuten] = box(corner=(-lgnd/2, -wgnd/2, 0mm), size=(lgnd-3mm, wgnd, h))
  substrate.subtract(feed_line_3)
  [feed_cover, port_cap].thicken(Cuthick)
  port_cap_ObjectFromFace1 = object_from(port_cap.face(at (0.5, 0, -1.0014)))
  port_cap_ObjectFromFace1_ObjectFromFace1 = object_from(port_cap_ObjectFromFace1.face)
  port_cap_ObjectFromFace1_ObjectFromFace1.thicken(Cuthick)
  port_cap.unite(port_cap_ObjectFromFace1_ObjectFromFace1)
  port_cap_ObjectFromFace1.delete()
  Rectangle1 = rectangle(corner=(-lmid/2, -wmid/2, h), x_size=lmid, y_size=wmid)
  Rectangle2 = rectangle(corner=(-lmid/2, -wmid1/2, h), x_size=-lmid1, y_size=wmid1)
  Rectangle3 = rectangle(corner=(lmid/2, -wmid1/2, h), x_size=lmid1, y_size=wmid1)
  Rectangle4 = rectangle(corner=(-(lmid/2+lmid1), -d/2, h), x_size=-d_width, y_size=d)
  Rectangle5 = rectangle(corner=((lmid/2+lmid1), -d/2, h), x_size=d_width, y_size=d)
  patch = rectangle(corner=(-wp/2, -sl/2+ml, 0mm), x_size=wp, y_size=lp)
  Rectangle10 = rectangle(corner=(mw/2, -sl/2+ml, 0mm), x_size=s, y_size=depth)
  Rectangle6 = rectangle(corner=(-mw/2, -sl/2+ml, 0mm), x_size=-s, y_size=depth)
  patch.subtract(Rectangle10, Rectangle6)
  Rectangle9 = rectangle(corner=(-mw/2, -sl/2, 0mm), x_size=mw, y_size=ml)
  patch.unite(Rectangle9)
  Rectangle8 = rectangle(corner=(-slotv_W/2, -sl/2+ml+lp-0.1mm, 0mm), x_size=slotv_W, y_size=-slotv_L)
  Rectangle7 = rectangle(corner=(-sloth_L/2, -sl/2+ml+lp-0.2mm, 0mm), x_size=sloth_L, y_size=-sloth_W)
  Rectangle8.unite(Rectangle7)
  patch.subtract(Rectangle8)
  patch.rotate(axis=Z, angle=90deg)
  patch.move(-5.027mm, -2.355mm, 0.05mm)
  patch1 = rectangle(corner=(-wp/2, -sl/2+ml, 0mm), x_size=wp, y_size=lp)
  Rectangle12 = rectangle(corner=(mw/2, -sl/2+ml, 0mm), x_size=s, y_size=depth)
  Rectangle13 = rectangle(corner=(-mw/2, -sl/2+ml, 0mm), x_size=-s, y_size=depth)
  patch1.subtract(Rectangle12, Rectangle13)
  Rectangle11 = rectangle(corner=(-mw/2, -sl/2, 0mm), x_size=mw, y_size=ml)
  patch1.unite(Rectangle11)
  Rectangle15 = rectangle(corner=(-slotv_W/2, -sl/2+ml+lp-0.1mm, 0mm), x_size=slotv_W, y_size=-slotv_L)
  Rectangle14 = rectangle(corner=(-sloth_L/2, -sl/2+ml+lp-0.2mm, 0mm), x_size=sloth_L, y_size=-sloth_W)
  Rectangle15.unite(Rectangle14)
  patch1.subtract(Rectangle15)
  patch1.rotate(axis=Z, angle=90deg)
  patch1.move(-5.027mm, -2.355mm, 0.05mm)
  patch1.move(4.4408921e-16mm, 4.71mm, 0mm)
  patch2 = rectangle(corner=(-wp/2, -sl/2+ml, 0mm), x_size=wp, y_size=lp)
  Rectangle17 = rectangle(corner=(mw/2, -sl/2+ml, 0mm), x_size=s, y_size=depth)
  Rectangle18 = rectangle(corner=(-mw/2, -sl/2+ml, 0mm), x_size=-s, y_size=depth)
  patch2.subtract(Rectangle17, Rectangle18)
  Rectangle16 = rectangle(corner=(-mw/2, -sl/2, 0mm), x_size=mw, y_size=ml)
  patch2.unite(Rectangle16)
  Rectangle20 = rectangle(corner=(-slotv_W/2, -sl/2+ml+lp-0.1mm, 0mm), x_size=slotv_W, y_size=-slotv_L)
  Rectangle19 = rectangle(corner=(-sloth_L/2, -sl/2+ml+lp-0.2mm, 0mm), x_size=sloth_L, y_size=-sloth_W)
  Rectangle20.unite(Rectangle19)
  patch2.subtract(Rectangle20)
  patch2.rotate(axis=Z, angle=90deg)
  patch2.move(-5.027mm, -2.355mm, 0.05mm)
  patch2.move(4.4408921e-16mm, 4.71mm, 0mm)
  patch2.move(5.794mm, 0mm, 0mm)
  patch3 = rectangle(corner=(-wp/2, -sl/2+ml, 0mm), x_size=wp, y_size=lp)
  Rectangle22 = rectangle(corner=(mw/2, -sl/2+ml, 0mm), x_size=s, y_size=depth)
  Rectangle23 = rectangle(corner=(-mw/2, -sl/2+ml, 0mm), x_size=-s, y_size=depth)
  patch3.subtract(Rectangle22, Rectangle23)
  Rectangle21 = rectangle(corner=(-mw/2, -sl/2, 0mm), x_size=mw, y_size=ml)
  patch3.unite(Rectangle21)
  Rectangle25 = rectangle(corner=(-slotv_W/2, -sl/2+ml+lp-0.1mm, 0mm), x_size=slotv_W, y_size=-slotv_L)
  Rectangle24 = rectangle(corner=(-sloth_L/2, -sl/2+ml+lp-0.2mm, 0mm), x_size=sloth_L, y_size=-sloth_W)
  Rectangle25.unite(Rectangle24)
  patch3.subtract(Rectangle25)
  patch3.rotate(axis=Z, angle=90deg)
  patch3.move(-5.027mm, -2.355mm, 0.05mm)
  patch3.move(4.4408921e-16mm, 4.71mm, 0mm)
  patch3.move(5.794mm, -4.71mm, 0mm)
  Rectangle2.unite(Rectangle4, Rectangle1, Rectangle5, Rectangle3, patch3, patch2, patch, patch1)
  Box2 [air] = box(corner=(-air/2, -air/2, -air/5), size=(air-3mm, air, 2*air/5))
boundaries and excitations:
  PerfE1: Perfect E Objects=ground
  Rad1: Radiation Objects=Box2
  PerfE2: Perfect E Objects=Rectangle2
  1: Wave Port Faces=port_cap.face(at (0, 0, -1)) WavePortType=Modal NumModes=1 Modes{Mode1{CharImp=Zpi RenormImp=50ohm}}
setups:
  Setup1: HfssDriven Frequency=105GHz MaxDeltaS=0.02 MaximumPasses=6 MinimumPasses=1 MinimumConvergedPasses=1 PercentRefinement=30 BasisOrder=1 PortAccuracy=2 DrivenSolverType="Direct Solver"
    sweep Sweep: 85GHz to 115GHz, 100 points; Type=Fast SaveFields
source amplitudes:
  1:1: 1V 0deg
