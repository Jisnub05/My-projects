# Ansys Electronics Desktop project, version 2024.2
materials:
  vacuum: permittivity=1
  Arlon AD270 (tm): permittivity=2.7 dielectric_loss_tangent=0.0023
  Teflon (tm): permittivity=2.1 dielectric_loss_tangent=0.001
  copper: permeability=0.999991 conductivity=58000000
  pec: conductivity=1e+30
  air: permittivity=1.0006 permeability=1.0000004
  Material1: permittivity=2.7
  Material2: permittivity=2.7 dielectric_loss_tangent=0.001
  Rogers RT/duroid 6002 (tm): permittivity=2.94 dielectric_loss_tangent=0.0012
  Rogers RT/duroid 6010/6010LM (tm): permittivity=10.2 dielectric_loss_tangent=0.0023
  Rogers RO3010 (tm): permittivity=10.2 dielectric_loss_tangent=0.0035
  quartz_glass: permittivity=3.78

design HFSSDesign1 (HFSS, HFSS Terminal Network, model units mm)
variables:
  lg = 0.8455mm
  wg = 1.409mm
  h = 0.197mm
  Cuthick = 0.0028mm
  rf = 0.113mm
  h1 = 0.17mm
  rf1 = 0.0355mm
  lmid = 1.08mm
  wmid = 0.07mm
  wmid1 = 0.14mm
  lmid1 = 0.282mm
  d = 1.736mm
  d_width = 0.045mm
  wslot_vert = 0.0395mm
  wf = 0.045mm
  d_mid = 0.377mm
  lp = 0.676mm
  lslot_hori = 0.586mm
  wp = 1.088mm
  wslot_hori = 0.0282mm
  d_in = -0.08475mm
  lpatch = 0.676mm
  wpatch = 1.088mm
  lgnd = 4.2mm
  wgnd = 4.2mm
geometry:
  ground = rectangle(corner=(-lgnd/2, -wgnd/2, 0mm), x_size=lgnd, y_size=wgnd)
  substrate [Rogers RO3010 (tm)] = box(corner=(-lgnd/2, -wgnd/2, 0mm), size=(lgnd, wgnd, h))
  feed_dielec [Teflon (tm)] = cylinder(axis=Z, base_centre=(0mm, 0mm, 0mm), radius=rf, height=-h1)
  feed_cover [copper] = object_from(feed_dielec.face(side))
  port_cap [pec] = object_from(feed_dielec.face(-z end))
  feed_line [copper] = cylinder(axis=Z, base_centre=(0mm, 0mm, -h1), radius=rf1, height=h1+h)
  feed_line_2 = feed_line.copy()
  feed_dielec.subtract(feed_line_2)
  [feed_cover, port_cap].thicken(Cuthick)
  port_cap_ObjectFromFace1 = object_from(port_cap.face(at (0.113, 0, -0.1714)))
  port_cap_ObjectFromFace1_ObjectFromFace1 = object_from(port_cap_ObjectFromFace1.face)
  port_cap_ObjectFromFace1.delete()
  port_cap_ObjectFromFace1_ObjectFromFace1.thicken(Cuthick)
  port_cap.unite(port_cap_ObjectFromFace1_ObjectFromFace1)
  feed_dielec_1 = feed_dielec.copy()
  ground.subtract(feed_dielec_1)
  feed_line_3 = feed_line.copy()
  substrate.subtract(feed_line_3)
  feed_line_4 = feed_line.copy()
  ground.subtract(feed_line_4)
  Rectangle1 = rectangle(corner=(-lmid/2, -wmid/2, h), x_size=lmid, y_size=wmid)
  Rectangle2 = rectangle(corner=(-lmid/2, -wmid1/2, h), x_size=-lmid1, y_size=wmid1)
  Rectangle3 = rectangle(corner=(lmid/2, -wmid1/2, h), x_size=lmid1, y_size=wmid1)
  Rectangle4 = rectangle(corner=(-(lmid/2+lmid1), -d/2, h), x_size=-d_width, y_size=d)
  Rectangle5 = rectangle(corner=((lmid/2+lmid1), -d/2, h), x_size=d_width, y_size=d)
  Rectangle9 = rectangle(corner=((-lg/2), -wf/2, h), x_size=(lg-lp)/2, y_size=wf)
  patch = rectangle(corner=(-lp/2, -wp/2, h), x_size=lp, y_size=wp)
  Rectangle9.unite(patch)
  Rectangle10 = rectangle(corner=(-(lslot_hori-(lp/2)), -(d_mid/2)-wslot_hori, h), x_size=-wslot_vert, y_size=d_mid+(2*wslot_hori))
  Rectangle11 = rectangle(corner=(((lpatch/2)-lslot_hori), -((wpatch/2)-d), h), x_size=lslot_hori, y_size=wslot_hori)
  Rectangle12 = rectangle(corner=(((lpatch/2)-lslot_hori), ((wpatch/2)-d), h), x_size=lslot_hori, y_size=-wslot_hori)
  Rectangle11.move(0mm, -1.0035mm, 0mm)
  Rectangle12.move(0mm, 1.0035mm, 0mm)
  Rectangle11.unite(Rectangle10, Rectangle12)
  Rectangle9.subtract(Rectangle11)
  Rectangle9.move(-0.44425mm, -0.8455mm, 0mm)
  Rectangle9.rotate(axis=Z, angle=180deg)
  Rectangle9.move(-1.734mm, -1.691mm, 0mm)
  Rectangle9_1 = Rectangle9.duplicate_along_line(step=(2.220446e-16mm, 1.691mm, 0mm), total=2)
  Rectangle9_2 = Rectangle9.duplicate_along_line(step=(1.689mm, -1.110223e-16mm, 0mm), total=2)
  Rectangle9_2_1 = Rectangle9_2.duplicate_along_line(step=(0mm, 1.691mm, 0mm), total=2)
  Rectangle9.unite(Rectangle9_1, Rectangle9_2, Rectangle9_2_1, Rectangle1..Rectangle5)
  Box1 [air] = box(corner=(-3mm, -3mm, -1mm), size=(6mm, 6mm, 2mm))
boundaries and excitations:
  PerfE1: Perfect E Objects=ground
  PerfE2: Perfect E Objects=Rectangle9
  Rad1: Radiation Objects=Box1
  1: Wave Port Faces=port_cap.face(at (0, 0, -0.17)) WavePortType=Modal NumModes=1 Modes{Mode1{CharImp=Zpi RenormImp=50ohm}}
setups:
  Setup1: HfssDriven Frequency=110GHz MaxDeltaS=0.02 MaximumPasses=12 MinimumPasses=1 MinimumConvergedPasses=1 PercentRefinement=30 BasisOrder=1 PortAccuracy=2 DrivenSolverType="Direct Solver"
    sweep Sweep: 100GHz to 120GHz, 150 points; Type=Fast SaveFields
source amplitudes:
  1:1: 1V 0deg
radiation setups:
  Infinite Sphere1: Infinite Sphere Theta=-90deg..90deg step 2deg Phi=-180deg..180deg step 2deg
reports:
  S Parameter Plot 1: dB(S(1,1)) vs Freq on Setup1 : Sweep; markers m1 at 108.05369GHz, m2 at 106.30872GHz, m3 at 115.03356GHz
  Gain Plot 1: GainTotal vs Freq on Setup1 : Sweep, Infinite Sphere1 [Phi=0deg Theta=0deg]; markers m1 at 106.3GHz, m2 at 107.91946GHz
  Gain Plot 2: dB(GainPhi), dB(GainTheta) vs Theta on Setup1 : Sweep, Infinite Sphere1 [Phi=0deg Freq=106.04GHz]
  Gain Plot 4: dB(GainPhi), dB(GainTheta) vs Theta on Setup1 : Sweep, Infinite Sphere1 [Phi=90deg Freq=106.04GHz]
  VSWR Plot 1: VSWR(1) vs Freq on Setup1 : Sweep; markers m1 at 106.3GHz
  Gain Plot 5: dB(GainTotal) vs Phi, Theta on Setup1 : Sweep, Infinite Sphere1 [Freq=106.309GHz]
